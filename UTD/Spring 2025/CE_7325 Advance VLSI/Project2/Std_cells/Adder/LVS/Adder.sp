* SPICE NETLIST
***************************************

.SUBCKT Adder GND! VDD! B0 A0 C_IN B1 A1 B2 A2 B3 A3 C_OUT OUT0 OUT1 OUT2 OUT3
** N=184 EP=16 IP=0 FDC=108
M0 42 B0 GND! GND! nmos_rvt L=2e-08 W=1.08e-07 nfin=4 $X=284 $Y=144 $D=1
M1 6 A0 42 GND! nmos_rvt L=2e-08 W=1.08e-07 nfin=4 $X=500 $Y=144 $D=1
M2 22 C_IN 6 GND! nmos_rvt L=2e-08 W=1.08e-07 nfin=4 $X=716 $Y=144 $D=1
M3 GND! A0 22 GND! nmos_rvt L=2e-08 W=1.08e-07 nfin=4 $X=932 $Y=144 $D=1
M4 22 B0 GND! GND! nmos_rvt L=2e-08 W=1.08e-07 nfin=4 $X=1148 $Y=144 $D=1
M5 24 A0 GND! GND! nmos_rvt L=2e-08 W=1.08e-07 nfin=4 $X=2228 $Y=144 $D=1
M6 GND! B0 24 GND! nmos_rvt L=2e-08 W=1.08e-07 nfin=4 $X=2444 $Y=144 $D=1
M7 24 C_IN GND! GND! nmos_rvt L=2e-08 W=1.08e-07 nfin=4 $X=2660 $Y=144 $D=1
M8 7 6 24 GND! nmos_rvt L=2e-08 W=1.08e-07 nfin=4 $X=2876 $Y=144 $D=1
M9 44 C_IN 7 GND! nmos_rvt L=2e-08 W=1.08e-07 nfin=4 $X=3092 $Y=144 $D=1
M10 46 B0 44 GND! nmos_rvt L=2e-08 W=1.08e-07 nfin=4 $X=3308 $Y=144 $D=1
M11 GND! A0 46 GND! nmos_rvt L=2e-08 W=1.08e-07 nfin=4 $X=3524 $Y=144 $D=1
M12 OUT0 7 GND! GND! nmos_rvt L=2e-08 W=1.08e-07 nfin=4 $X=4604 $Y=144 $D=1
M13 10 B1 GND! GND! nmos_rvt L=2e-08 W=1.08e-07 nfin=4 $X=5684 $Y=144 $D=1
M14 11 A1 GND! GND! nmos_rvt L=2e-08 W=1.08e-07 nfin=4 $X=6764 $Y=144 $D=1
M15 51 10 GND! GND! nmos_rvt L=2e-08 W=1.08e-07 nfin=4 $X=7844 $Y=144 $D=1
M16 12 11 51 GND! nmos_rvt L=2e-08 W=1.08e-07 nfin=4 $X=8060 $Y=144 $D=1
M17 27 6 12 GND! nmos_rvt L=2e-08 W=1.08e-07 nfin=4 $X=8276 $Y=144 $D=1
M18 GND! 11 27 GND! nmos_rvt L=2e-08 W=1.08e-07 nfin=4 $X=8492 $Y=144 $D=1
M19 27 10 GND! GND! nmos_rvt L=2e-08 W=1.08e-07 nfin=4 $X=8708 $Y=144 $D=1
M20 29 11 GND! GND! nmos_rvt L=2e-08 W=1.08e-07 nfin=4 $X=9788 $Y=144 $D=1
M21 GND! 10 29 GND! nmos_rvt L=2e-08 W=1.08e-07 nfin=4 $X=10004 $Y=144 $D=1
M22 29 6 GND! GND! nmos_rvt L=2e-08 W=1.08e-07 nfin=4 $X=10220 $Y=144 $D=1
M23 OUT1 12 29 GND! nmos_rvt L=2e-08 W=1.08e-07 nfin=4 $X=10436 $Y=144 $D=1
M24 53 6 OUT1 GND! nmos_rvt L=2e-08 W=1.08e-07 nfin=4 $X=10652 $Y=144 $D=1
M25 55 10 53 GND! nmos_rvt L=2e-08 W=1.08e-07 nfin=4 $X=10868 $Y=144 $D=1
M26 GND! 11 55 GND! nmos_rvt L=2e-08 W=1.08e-07 nfin=4 $X=11084 $Y=144 $D=1
M27 57 B2 GND! GND! nmos_rvt L=2e-08 W=1.08e-07 nfin=4 $X=12164 $Y=144 $D=1
M28 15 A2 57 GND! nmos_rvt L=2e-08 W=1.08e-07 nfin=4 $X=12380 $Y=144 $D=1
M29 32 12 15 GND! nmos_rvt L=2e-08 W=1.08e-07 nfin=4 $X=12596 $Y=144 $D=1
M30 GND! A2 32 GND! nmos_rvt L=2e-08 W=1.08e-07 nfin=4 $X=12812 $Y=144 $D=1
M31 32 B2 GND! GND! nmos_rvt L=2e-08 W=1.08e-07 nfin=4 $X=13028 $Y=144 $D=1
M32 34 A2 GND! GND! nmos_rvt L=2e-08 W=1.08e-07 nfin=4 $X=14108 $Y=144 $D=1
M33 GND! B2 34 GND! nmos_rvt L=2e-08 W=1.08e-07 nfin=4 $X=14324 $Y=144 $D=1
M34 34 12 GND! GND! nmos_rvt L=2e-08 W=1.08e-07 nfin=4 $X=14540 $Y=144 $D=1
M35 16 15 34 GND! nmos_rvt L=2e-08 W=1.08e-07 nfin=4 $X=14756 $Y=144 $D=1
M36 59 12 16 GND! nmos_rvt L=2e-08 W=1.08e-07 nfin=4 $X=14972 $Y=144 $D=1
M37 61 B2 59 GND! nmos_rvt L=2e-08 W=1.08e-07 nfin=4 $X=15188 $Y=144 $D=1
M38 GND! A2 61 GND! nmos_rvt L=2e-08 W=1.08e-07 nfin=4 $X=15404 $Y=144 $D=1
M39 OUT2 16 GND! GND! nmos_rvt L=2e-08 W=1.08e-07 nfin=4 $X=16484 $Y=144 $D=1
M40 19 B3 GND! GND! nmos_rvt L=2e-08 W=1.08e-07 nfin=4 $X=17564 $Y=144 $D=1
M41 20 A3 GND! GND! nmos_rvt L=2e-08 W=1.08e-07 nfin=4 $X=18644 $Y=144 $D=1
M42 66 19 GND! GND! nmos_rvt L=2e-08 W=1.08e-07 nfin=4 $X=19724 $Y=144 $D=1
M43 C_OUT 20 66 GND! nmos_rvt L=2e-08 W=1.08e-07 nfin=4 $X=19940 $Y=144 $D=1
M44 37 15 C_OUT GND! nmos_rvt L=2e-08 W=1.08e-07 nfin=4 $X=20156 $Y=144 $D=1
M45 GND! 20 37 GND! nmos_rvt L=2e-08 W=1.08e-07 nfin=4 $X=20372 $Y=144 $D=1
M46 37 19 GND! GND! nmos_rvt L=2e-08 W=1.08e-07 nfin=4 $X=20588 $Y=144 $D=1
M47 39 20 GND! GND! nmos_rvt L=2e-08 W=1.08e-07 nfin=4 $X=21668 $Y=144 $D=1
M48 GND! 19 39 GND! nmos_rvt L=2e-08 W=1.08e-07 nfin=4 $X=21884 $Y=144 $D=1
M49 39 15 GND! GND! nmos_rvt L=2e-08 W=1.08e-07 nfin=4 $X=22100 $Y=144 $D=1
M50 OUT3 C_OUT 39 GND! nmos_rvt L=2e-08 W=1.08e-07 nfin=4 $X=22316 $Y=144 $D=1
M51 68 15 OUT3 GND! nmos_rvt L=2e-08 W=1.08e-07 nfin=4 $X=22532 $Y=144 $D=1
M52 70 19 68 GND! nmos_rvt L=2e-08 W=1.08e-07 nfin=4 $X=22748 $Y=144 $D=1
M53 GND! 20 70 GND! nmos_rvt L=2e-08 W=1.08e-07 nfin=4 $X=22964 $Y=144 $D=1
M54 43 B0 VDD! VDD! pmos_rvt L=2e-08 W=1.08e-07 nfin=4 $X=284 $Y=792 $D=0
M55 6 A0 43 VDD! pmos_rvt L=2e-08 W=1.08e-07 nfin=4 $X=500 $Y=792 $D=0
M56 23 C_IN 6 VDD! pmos_rvt L=2e-08 W=1.08e-07 nfin=4 $X=716 $Y=792 $D=0
M57 VDD! A0 23 VDD! pmos_rvt L=2e-08 W=1.08e-07 nfin=4 $X=932 $Y=792 $D=0
M58 23 B0 VDD! VDD! pmos_rvt L=2e-08 W=1.08e-07 nfin=4 $X=1148 $Y=792 $D=0
M59 25 A0 VDD! VDD! pmos_rvt L=2e-08 W=1.08e-07 nfin=4 $X=2228 $Y=792 $D=0
M60 VDD! B0 25 VDD! pmos_rvt L=2e-08 W=1.08e-07 nfin=4 $X=2444 $Y=792 $D=0
M61 25 C_IN VDD! VDD! pmos_rvt L=2e-08 W=1.08e-07 nfin=4 $X=2660 $Y=792 $D=0
M62 7 6 25 VDD! pmos_rvt L=2e-08 W=1.08e-07 nfin=4 $X=2876 $Y=792 $D=0
M63 45 C_IN 7 VDD! pmos_rvt L=2e-08 W=1.08e-07 nfin=4 $X=3092 $Y=792 $D=0
M64 47 B0 45 VDD! pmos_rvt L=2e-08 W=1.08e-07 nfin=4 $X=3308 $Y=792 $D=0
M65 VDD! A0 47 VDD! pmos_rvt L=2e-08 W=1.08e-07 nfin=4 $X=3524 $Y=792 $D=0
M66 OUT0 7 VDD! VDD! pmos_rvt L=2e-08 W=1.08e-07 nfin=4 $X=4604 $Y=792 $D=0
M67 10 B1 VDD! VDD! pmos_rvt L=2e-08 W=1.08e-07 nfin=4 $X=5684 $Y=792 $D=0
M68 11 A1 VDD! VDD! pmos_rvt L=2e-08 W=1.08e-07 nfin=4 $X=6764 $Y=792 $D=0
M69 52 10 VDD! VDD! pmos_rvt L=2e-08 W=1.08e-07 nfin=4 $X=7844 $Y=792 $D=0
M70 12 11 52 VDD! pmos_rvt L=2e-08 W=1.08e-07 nfin=4 $X=8060 $Y=792 $D=0
M71 28 6 12 VDD! pmos_rvt L=2e-08 W=1.08e-07 nfin=4 $X=8276 $Y=792 $D=0
M72 VDD! 11 28 VDD! pmos_rvt L=2e-08 W=1.08e-07 nfin=4 $X=8492 $Y=792 $D=0
M73 28 10 VDD! VDD! pmos_rvt L=2e-08 W=1.08e-07 nfin=4 $X=8708 $Y=792 $D=0
M74 30 11 VDD! VDD! pmos_rvt L=2e-08 W=1.08e-07 nfin=4 $X=9788 $Y=792 $D=0
M75 VDD! 10 30 VDD! pmos_rvt L=2e-08 W=1.08e-07 nfin=4 $X=10004 $Y=792 $D=0
M76 30 6 VDD! VDD! pmos_rvt L=2e-08 W=1.08e-07 nfin=4 $X=10220 $Y=792 $D=0
M77 OUT1 12 30 VDD! pmos_rvt L=2e-08 W=1.08e-07 nfin=4 $X=10436 $Y=792 $D=0
M78 54 6 OUT1 VDD! pmos_rvt L=2e-08 W=1.08e-07 nfin=4 $X=10652 $Y=792 $D=0
M79 56 10 54 VDD! pmos_rvt L=2e-08 W=1.08e-07 nfin=4 $X=10868 $Y=792 $D=0
M80 VDD! 11 56 VDD! pmos_rvt L=2e-08 W=1.08e-07 nfin=4 $X=11084 $Y=792 $D=0
M81 58 B2 VDD! VDD! pmos_rvt L=2e-08 W=1.08e-07 nfin=4 $X=12164 $Y=792 $D=0
M82 15 A2 58 VDD! pmos_rvt L=2e-08 W=1.08e-07 nfin=4 $X=12380 $Y=792 $D=0
M83 33 12 15 VDD! pmos_rvt L=2e-08 W=1.08e-07 nfin=4 $X=12596 $Y=792 $D=0
M84 VDD! A2 33 VDD! pmos_rvt L=2e-08 W=1.08e-07 nfin=4 $X=12812 $Y=792 $D=0
M85 33 B2 VDD! VDD! pmos_rvt L=2e-08 W=1.08e-07 nfin=4 $X=13028 $Y=792 $D=0
M86 35 A2 VDD! VDD! pmos_rvt L=2e-08 W=1.08e-07 nfin=4 $X=14108 $Y=792 $D=0
M87 VDD! B2 35 VDD! pmos_rvt L=2e-08 W=1.08e-07 nfin=4 $X=14324 $Y=792 $D=0
M88 35 12 VDD! VDD! pmos_rvt L=2e-08 W=1.08e-07 nfin=4 $X=14540 $Y=792 $D=0
M89 16 15 35 VDD! pmos_rvt L=2e-08 W=1.08e-07 nfin=4 $X=14756 $Y=792 $D=0
M90 60 12 16 VDD! pmos_rvt L=2e-08 W=1.08e-07 nfin=4 $X=14972 $Y=792 $D=0
M91 62 B2 60 VDD! pmos_rvt L=2e-08 W=1.08e-07 nfin=4 $X=15188 $Y=792 $D=0
M92 VDD! A2 62 VDD! pmos_rvt L=2e-08 W=1.08e-07 nfin=4 $X=15404 $Y=792 $D=0
M93 OUT2 16 VDD! VDD! pmos_rvt L=2e-08 W=1.08e-07 nfin=4 $X=16484 $Y=792 $D=0
M94 19 B3 VDD! VDD! pmos_rvt L=2e-08 W=1.08e-07 nfin=4 $X=17564 $Y=792 $D=0
M95 20 A3 VDD! VDD! pmos_rvt L=2e-08 W=1.08e-07 nfin=4 $X=18644 $Y=792 $D=0
M96 67 19 VDD! VDD! pmos_rvt L=2e-08 W=1.08e-07 nfin=4 $X=19724 $Y=792 $D=0
M97 C_OUT 20 67 VDD! pmos_rvt L=2e-08 W=1.08e-07 nfin=4 $X=19940 $Y=792 $D=0
M98 38 15 C_OUT VDD! pmos_rvt L=2e-08 W=1.08e-07 nfin=4 $X=20156 $Y=792 $D=0
M99 VDD! 20 38 VDD! pmos_rvt L=2e-08 W=1.08e-07 nfin=4 $X=20372 $Y=792 $D=0
M100 38 19 VDD! VDD! pmos_rvt L=2e-08 W=1.08e-07 nfin=4 $X=20588 $Y=792 $D=0
M101 40 20 VDD! VDD! pmos_rvt L=2e-08 W=1.08e-07 nfin=4 $X=21668 $Y=792 $D=0
M102 VDD! 19 40 VDD! pmos_rvt L=2e-08 W=1.08e-07 nfin=4 $X=21884 $Y=792 $D=0
M103 40 15 VDD! VDD! pmos_rvt L=2e-08 W=1.08e-07 nfin=4 $X=22100 $Y=792 $D=0
M104 OUT3 C_OUT 40 VDD! pmos_rvt L=2e-08 W=1.08e-07 nfin=4 $X=22316 $Y=792 $D=0
M105 69 15 OUT3 VDD! pmos_rvt L=2e-08 W=1.08e-07 nfin=4 $X=22532 $Y=792 $D=0
M106 71 19 69 VDD! pmos_rvt L=2e-08 W=1.08e-07 nfin=4 $X=22748 $Y=792 $D=0
M107 VDD! 20 71 VDD! pmos_rvt L=2e-08 W=1.08e-07 nfin=4 $X=22964 $Y=792 $D=0
.ENDS
***************************************
