* SPICE NETLIST
***************************************

.SUBCKT CSA GND! VDD! B8 B4 B0 A8 A4 A0 CARRY B9 B5 B1 A9 A5 A1 B10 B6 B2 A10 A6
+ A2 B11 B7 B3 A11 A7 A3 S0 S8 S4 S1 S9 S5 S2 S10 S6 S3 S11 S7 S12
** N=1299 EP=40 IP=0 FDC=680
M0 218 B8 GND! GND! nmos_rvt L=2e-08 W=1.08e-07 nfin=4 $X=284 $Y=-10696 $D=1
M1 220 B8 GND! GND! nmos_rvt L=2e-08 W=1.08e-07 nfin=4 $X=284 $Y=-8528 $D=1
M2 222 B4 GND! GND! nmos_rvt L=2e-08 W=1.08e-07 nfin=4 $X=284 $Y=-4192 $D=1
M3 224 B4 GND! GND! nmos_rvt L=2e-08 W=1.08e-07 nfin=4 $X=284 $Y=-2024 $D=1
M4 226 B0 GND! GND! nmos_rvt L=2e-08 W=1.08e-07 nfin=4 $X=284 $Y=144 $D=1
M5 10 A8 218 GND! nmos_rvt L=2e-08 W=1.08e-07 nfin=4 $X=500 $Y=-10696 $D=1
M6 11 A8 220 GND! nmos_rvt L=2e-08 W=1.08e-07 nfin=4 $X=500 $Y=-8528 $D=1
M7 12 A4 222 GND! nmos_rvt L=2e-08 W=1.08e-07 nfin=4 $X=500 $Y=-4192 $D=1
M8 13 A4 224 GND! nmos_rvt L=2e-08 W=1.08e-07 nfin=4 $X=500 $Y=-2024 $D=1
M9 14 A0 226 GND! nmos_rvt L=2e-08 W=1.08e-07 nfin=4 $X=500 $Y=144 $D=1
M10 123 VDD! 10 GND! nmos_rvt L=2e-08 W=1.08e-07 nfin=4 $X=716 $Y=-10696 $D=1
M11 125 GND! 11 GND! nmos_rvt L=2e-08 W=1.08e-07 nfin=4 $X=716 $Y=-8528 $D=1
M12 127 VDD! 12 GND! nmos_rvt L=2e-08 W=1.08e-07 nfin=4 $X=716 $Y=-4192 $D=1
M13 129 GND! 13 GND! nmos_rvt L=2e-08 W=1.08e-07 nfin=4 $X=716 $Y=-2024 $D=1
M14 131 CARRY 14 GND! nmos_rvt L=2e-08 W=1.08e-07 nfin=4 $X=716 $Y=144 $D=1
M15 GND! A8 123 GND! nmos_rvt L=2e-08 W=1.08e-07 nfin=4 $X=932 $Y=-10696 $D=1
M16 GND! A8 125 GND! nmos_rvt L=2e-08 W=1.08e-07 nfin=4 $X=932 $Y=-8528 $D=1
M17 GND! A4 127 GND! nmos_rvt L=2e-08 W=1.08e-07 nfin=4 $X=932 $Y=-4192 $D=1
M18 GND! A4 129 GND! nmos_rvt L=2e-08 W=1.08e-07 nfin=4 $X=932 $Y=-2024 $D=1
M19 GND! A0 131 GND! nmos_rvt L=2e-08 W=1.08e-07 nfin=4 $X=932 $Y=144 $D=1
M20 123 B8 GND! GND! nmos_rvt L=2e-08 W=1.08e-07 nfin=4 $X=1148 $Y=-10696 $D=1
M21 125 B8 GND! GND! nmos_rvt L=2e-08 W=1.08e-07 nfin=4 $X=1148 $Y=-8528 $D=1
M22 127 B4 GND! GND! nmos_rvt L=2e-08 W=1.08e-07 nfin=4 $X=1148 $Y=-4192 $D=1
M23 129 B4 GND! GND! nmos_rvt L=2e-08 W=1.08e-07 nfin=4 $X=1148 $Y=-2024 $D=1
M24 131 B0 GND! GND! nmos_rvt L=2e-08 W=1.08e-07 nfin=4 $X=1148 $Y=144 $D=1
M25 133 A8 GND! GND! nmos_rvt L=2e-08 W=1.08e-07 nfin=4 $X=2228 $Y=-10696 $D=1
M26 135 A8 GND! GND! nmos_rvt L=2e-08 W=1.08e-07 nfin=4 $X=2228 $Y=-8528 $D=1
M27 137 A4 GND! GND! nmos_rvt L=2e-08 W=1.08e-07 nfin=4 $X=2228 $Y=-4192 $D=1
M28 139 A4 GND! GND! nmos_rvt L=2e-08 W=1.08e-07 nfin=4 $X=2228 $Y=-2024 $D=1
M29 141 A0 GND! GND! nmos_rvt L=2e-08 W=1.08e-07 nfin=4 $X=2228 $Y=144 $D=1
M30 GND! B8 133 GND! nmos_rvt L=2e-08 W=1.08e-07 nfin=4 $X=2444 $Y=-10696 $D=1
M31 GND! B8 135 GND! nmos_rvt L=2e-08 W=1.08e-07 nfin=4 $X=2444 $Y=-8528 $D=1
M32 GND! B4 137 GND! nmos_rvt L=2e-08 W=1.08e-07 nfin=4 $X=2444 $Y=-4192 $D=1
M33 GND! B4 139 GND! nmos_rvt L=2e-08 W=1.08e-07 nfin=4 $X=2444 $Y=-2024 $D=1
M34 GND! B0 141 GND! nmos_rvt L=2e-08 W=1.08e-07 nfin=4 $X=2444 $Y=144 $D=1
M35 133 VDD! GND! GND! nmos_rvt L=2e-08 W=1.08e-07 nfin=4 $X=2660 $Y=-10696 $D=1
M36 135 GND! GND! GND! nmos_rvt L=2e-08 W=1.08e-07 nfin=4 $X=2660 $Y=-8528 $D=1
M37 137 VDD! GND! GND! nmos_rvt L=2e-08 W=1.08e-07 nfin=4 $X=2660 $Y=-4192 $D=1
M38 139 GND! GND! GND! nmos_rvt L=2e-08 W=1.08e-07 nfin=4 $X=2660 $Y=-2024 $D=1
M39 141 CARRY GND! GND! nmos_rvt L=2e-08 W=1.08e-07 nfin=4 $X=2660 $Y=144 $D=1
M40 19 10 133 GND! nmos_rvt L=2e-08 W=1.08e-07 nfin=4 $X=2876 $Y=-10696 $D=1
M41 20 11 135 GND! nmos_rvt L=2e-08 W=1.08e-07 nfin=4 $X=2876 $Y=-8528 $D=1
M42 21 12 137 GND! nmos_rvt L=2e-08 W=1.08e-07 nfin=4 $X=2876 $Y=-4192 $D=1
M43 22 13 139 GND! nmos_rvt L=2e-08 W=1.08e-07 nfin=4 $X=2876 $Y=-2024 $D=1
M44 23 14 141 GND! nmos_rvt L=2e-08 W=1.08e-07 nfin=4 $X=2876 $Y=144 $D=1
M45 228 VDD! 19 GND! nmos_rvt L=2e-08 W=1.08e-07 nfin=4 $X=3092 $Y=-10696 $D=1
M46 230 GND! 20 GND! nmos_rvt L=2e-08 W=1.08e-07 nfin=4 $X=3092 $Y=-8528 $D=1
M47 232 VDD! 21 GND! nmos_rvt L=2e-08 W=1.08e-07 nfin=4 $X=3092 $Y=-4192 $D=1
M48 234 GND! 22 GND! nmos_rvt L=2e-08 W=1.08e-07 nfin=4 $X=3092 $Y=-2024 $D=1
M49 236 CARRY 23 GND! nmos_rvt L=2e-08 W=1.08e-07 nfin=4 $X=3092 $Y=144 $D=1
M50 238 B8 228 GND! nmos_rvt L=2e-08 W=1.08e-07 nfin=4 $X=3308 $Y=-10696 $D=1
M51 240 B8 230 GND! nmos_rvt L=2e-08 W=1.08e-07 nfin=4 $X=3308 $Y=-8528 $D=1
M52 242 B4 232 GND! nmos_rvt L=2e-08 W=1.08e-07 nfin=4 $X=3308 $Y=-4192 $D=1
M53 244 B4 234 GND! nmos_rvt L=2e-08 W=1.08e-07 nfin=4 $X=3308 $Y=-2024 $D=1
M54 246 B0 236 GND! nmos_rvt L=2e-08 W=1.08e-07 nfin=4 $X=3308 $Y=144 $D=1
M55 GND! A8 238 GND! nmos_rvt L=2e-08 W=1.08e-07 nfin=4 $X=3524 $Y=-10696 $D=1
M56 GND! A8 240 GND! nmos_rvt L=2e-08 W=1.08e-07 nfin=4 $X=3524 $Y=-8528 $D=1
M57 GND! A4 242 GND! nmos_rvt L=2e-08 W=1.08e-07 nfin=4 $X=3524 $Y=-4192 $D=1
M58 GND! A4 244 GND! nmos_rvt L=2e-08 W=1.08e-07 nfin=4 $X=3524 $Y=-2024 $D=1
M59 GND! A0 246 GND! nmos_rvt L=2e-08 W=1.08e-07 nfin=4 $X=3524 $Y=144 $D=1
M60 GND! 15 24 GND! nmos_rvt L=2e-08 W=1.08e-07 nfin=4 $X=4172 $Y=-12864 $D=1
M61 GND! 16 25 GND! nmos_rvt L=2e-08 W=1.08e-07 nfin=4 $X=4172 $Y=-6360 $D=1
M62 248 17 GND! GND! nmos_rvt L=2e-08 W=1.08e-07 nfin=4 $X=4388 $Y=-12864 $D=1
M63 250 18 GND! GND! nmos_rvt L=2e-08 W=1.08e-07 nfin=4 $X=4388 $Y=-6360 $D=1
M64 26 19 GND! GND! nmos_rvt L=2e-08 W=1.08e-07 nfin=4 $X=4604 $Y=-10696 $D=1
M65 17 20 GND! GND! nmos_rvt L=2e-08 W=1.08e-07 nfin=4 $X=4604 $Y=-8528 $D=1
M66 27 21 GND! GND! nmos_rvt L=2e-08 W=1.08e-07 nfin=4 $X=4604 $Y=-4192 $D=1
M67 18 22 GND! GND! nmos_rvt L=2e-08 W=1.08e-07 nfin=4 $X=4604 $Y=-2024 $D=1
M68 S0 23 GND! GND! nmos_rvt L=2e-08 W=1.08e-07 nfin=4 $X=4604 $Y=144 $D=1
M69 28 24 248 GND! nmos_rvt L=2e-08 W=1.08e-07 nfin=4 $X=4820 $Y=-12864 $D=1
M70 30 25 250 GND! nmos_rvt L=2e-08 W=1.08e-07 nfin=4 $X=4820 $Y=-6360 $D=1
M71 257 15 28 GND! nmos_rvt L=2e-08 W=1.08e-07 nfin=4 $X=5036 $Y=-12864 $D=1
M72 258 16 30 GND! nmos_rvt L=2e-08 W=1.08e-07 nfin=4 $X=5036 $Y=-6360 $D=1
M73 GND! 26 257 GND! nmos_rvt L=2e-08 W=1.08e-07 nfin=4 $X=5468 $Y=-12864 $D=1
M74 GND! 27 258 GND! nmos_rvt L=2e-08 W=1.08e-07 nfin=4 $X=5468 $Y=-6360 $D=1
M75 S8 28 GND! GND! nmos_rvt L=2e-08 W=1.08e-07 nfin=4 $X=5684 $Y=-12864 $D=1
M76 38 B9 GND! GND! nmos_rvt L=2e-08 W=1.08e-07 nfin=4 $X=5684 $Y=-10696 $D=1
M77 39 B9 GND! GND! nmos_rvt L=2e-08 W=1.08e-07 nfin=4 $X=5684 $Y=-8528 $D=1
M78 S4 30 GND! GND! nmos_rvt L=2e-08 W=1.08e-07 nfin=4 $X=5684 $Y=-6360 $D=1
M79 40 B5 GND! GND! nmos_rvt L=2e-08 W=1.08e-07 nfin=4 $X=5684 $Y=-4192 $D=1
M80 41 B5 GND! GND! nmos_rvt L=2e-08 W=1.08e-07 nfin=4 $X=5684 $Y=-2024 $D=1
M81 42 B1 GND! GND! nmos_rvt L=2e-08 W=1.08e-07 nfin=4 $X=5684 $Y=144 $D=1
M82 43 A9 GND! GND! nmos_rvt L=2e-08 W=1.08e-07 nfin=4 $X=6764 $Y=-10696 $D=1
M83 44 A9 GND! GND! nmos_rvt L=2e-08 W=1.08e-07 nfin=4 $X=6764 $Y=-8528 $D=1
M84 45 A5 GND! GND! nmos_rvt L=2e-08 W=1.08e-07 nfin=4 $X=6764 $Y=-4192 $D=1
M85 46 A5 GND! GND! nmos_rvt L=2e-08 W=1.08e-07 nfin=4 $X=6764 $Y=-2024 $D=1
M86 47 A1 GND! GND! nmos_rvt L=2e-08 W=1.08e-07 nfin=4 $X=6764 $Y=144 $D=1
M87 15 36 GND! GND! nmos_rvt L=2e-08 W=1.08e-07 nfin=4 $X=7196 $Y=-12864 $D=1
M88 16 37 GND! GND! nmos_rvt L=2e-08 W=1.08e-07 nfin=4 $X=7196 $Y=-6360 $D=1
M89 273 38 GND! GND! nmos_rvt L=2e-08 W=1.08e-07 nfin=4 $X=7844 $Y=-10696 $D=1
M90 275 39 GND! GND! nmos_rvt L=2e-08 W=1.08e-07 nfin=4 $X=7844 $Y=-8528 $D=1
M91 277 40 GND! GND! nmos_rvt L=2e-08 W=1.08e-07 nfin=4 $X=7844 $Y=-4192 $D=1
M92 279 41 GND! GND! nmos_rvt L=2e-08 W=1.08e-07 nfin=4 $X=7844 $Y=-2024 $D=1
M93 281 42 GND! GND! nmos_rvt L=2e-08 W=1.08e-07 nfin=4 $X=7844 $Y=144 $D=1
M94 48 43 273 GND! nmos_rvt L=2e-08 W=1.08e-07 nfin=4 $X=8060 $Y=-10696 $D=1
M95 49 44 275 GND! nmos_rvt L=2e-08 W=1.08e-07 nfin=4 $X=8060 $Y=-8528 $D=1
M96 50 45 277 GND! nmos_rvt L=2e-08 W=1.08e-07 nfin=4 $X=8060 $Y=-4192 $D=1
M97 51 46 279 GND! nmos_rvt L=2e-08 W=1.08e-07 nfin=4 $X=8060 $Y=-2024 $D=1
M98 52 47 281 GND! nmos_rvt L=2e-08 W=1.08e-07 nfin=4 $X=8060 $Y=144 $D=1
M99 146 10 48 GND! nmos_rvt L=2e-08 W=1.08e-07 nfin=4 $X=8276 $Y=-10696 $D=1
M100 148 11 49 GND! nmos_rvt L=2e-08 W=1.08e-07 nfin=4 $X=8276 $Y=-8528 $D=1
M101 150 12 50 GND! nmos_rvt L=2e-08 W=1.08e-07 nfin=4 $X=8276 $Y=-4192 $D=1
M102 152 13 51 GND! nmos_rvt L=2e-08 W=1.08e-07 nfin=4 $X=8276 $Y=-2024 $D=1
M103 154 14 52 GND! nmos_rvt L=2e-08 W=1.08e-07 nfin=4 $X=8276 $Y=144 $D=1
M104 GND! 43 146 GND! nmos_rvt L=2e-08 W=1.08e-07 nfin=4 $X=8492 $Y=-10696 $D=1
M105 GND! 44 148 GND! nmos_rvt L=2e-08 W=1.08e-07 nfin=4 $X=8492 $Y=-8528 $D=1
M106 GND! 45 150 GND! nmos_rvt L=2e-08 W=1.08e-07 nfin=4 $X=8492 $Y=-4192 $D=1
M107 GND! 46 152 GND! nmos_rvt L=2e-08 W=1.08e-07 nfin=4 $X=8492 $Y=-2024 $D=1
M108 GND! 47 154 GND! nmos_rvt L=2e-08 W=1.08e-07 nfin=4 $X=8492 $Y=144 $D=1
M109 146 38 GND! GND! nmos_rvt L=2e-08 W=1.08e-07 nfin=4 $X=8708 $Y=-10696 $D=1
M110 148 39 GND! GND! nmos_rvt L=2e-08 W=1.08e-07 nfin=4 $X=8708 $Y=-8528 $D=1
M111 150 40 GND! GND! nmos_rvt L=2e-08 W=1.08e-07 nfin=4 $X=8708 $Y=-4192 $D=1
M112 152 41 GND! GND! nmos_rvt L=2e-08 W=1.08e-07 nfin=4 $X=8708 $Y=-2024 $D=1
M113 154 42 GND! GND! nmos_rvt L=2e-08 W=1.08e-07 nfin=4 $X=8708 $Y=144 $D=1
M114 156 43 GND! GND! nmos_rvt L=2e-08 W=1.08e-07 nfin=4 $X=9788 $Y=-10696 $D=1
M115 158 44 GND! GND! nmos_rvt L=2e-08 W=1.08e-07 nfin=4 $X=9788 $Y=-8528 $D=1
M116 160 45 GND! GND! nmos_rvt L=2e-08 W=1.08e-07 nfin=4 $X=9788 $Y=-4192 $D=1
M117 162 46 GND! GND! nmos_rvt L=2e-08 W=1.08e-07 nfin=4 $X=9788 $Y=-2024 $D=1
M118 164 47 GND! GND! nmos_rvt L=2e-08 W=1.08e-07 nfin=4 $X=9788 $Y=144 $D=1
M119 GND! 38 156 GND! nmos_rvt L=2e-08 W=1.08e-07 nfin=4 $X=10004 $Y=-10696 $D=1
M120 GND! 39 158 GND! nmos_rvt L=2e-08 W=1.08e-07 nfin=4 $X=10004 $Y=-8528 $D=1
M121 GND! 40 160 GND! nmos_rvt L=2e-08 W=1.08e-07 nfin=4 $X=10004 $Y=-4192 $D=1
M122 GND! 41 162 GND! nmos_rvt L=2e-08 W=1.08e-07 nfin=4 $X=10004 $Y=-2024 $D=1
M123 GND! 42 164 GND! nmos_rvt L=2e-08 W=1.08e-07 nfin=4 $X=10004 $Y=144 $D=1
M124 156 10 GND! GND! nmos_rvt L=2e-08 W=1.08e-07 nfin=4 $X=10220 $Y=-10696 $D=1
M125 158 11 GND! GND! nmos_rvt L=2e-08 W=1.08e-07 nfin=4 $X=10220 $Y=-8528 $D=1
M126 160 12 GND! GND! nmos_rvt L=2e-08 W=1.08e-07 nfin=4 $X=10220 $Y=-4192 $D=1
M127 162 13 GND! GND! nmos_rvt L=2e-08 W=1.08e-07 nfin=4 $X=10220 $Y=-2024 $D=1
M128 164 14 GND! GND! nmos_rvt L=2e-08 W=1.08e-07 nfin=4 $X=10220 $Y=144 $D=1
M129 GND! 15 55 GND! nmos_rvt L=2e-08 W=1.08e-07 nfin=4 $X=10436 $Y=-12864 $D=1
M130 57 48 156 GND! nmos_rvt L=2e-08 W=1.08e-07 nfin=4 $X=10436 $Y=-10696 $D=1
M131 53 49 158 GND! nmos_rvt L=2e-08 W=1.08e-07 nfin=4 $X=10436 $Y=-8528 $D=1
M132 GND! 16 56 GND! nmos_rvt L=2e-08 W=1.08e-07 nfin=4 $X=10436 $Y=-6360 $D=1
M133 58 50 160 GND! nmos_rvt L=2e-08 W=1.08e-07 nfin=4 $X=10436 $Y=-4192 $D=1
M134 54 51 162 GND! nmos_rvt L=2e-08 W=1.08e-07 nfin=4 $X=10436 $Y=-2024 $D=1
M135 S1 52 164 GND! nmos_rvt L=2e-08 W=1.08e-07 nfin=4 $X=10436 $Y=144 $D=1
M136 283 53 GND! GND! nmos_rvt L=2e-08 W=1.08e-07 nfin=4 $X=10652 $Y=-12864 $D=1
M137 285 10 57 GND! nmos_rvt L=2e-08 W=1.08e-07 nfin=4 $X=10652 $Y=-10696 $D=1
M138 287 11 53 GND! nmos_rvt L=2e-08 W=1.08e-07 nfin=4 $X=10652 $Y=-8528 $D=1
M139 289 54 GND! GND! nmos_rvt L=2e-08 W=1.08e-07 nfin=4 $X=10652 $Y=-6360 $D=1
M140 291 12 58 GND! nmos_rvt L=2e-08 W=1.08e-07 nfin=4 $X=10652 $Y=-4192 $D=1
M141 293 13 54 GND! nmos_rvt L=2e-08 W=1.08e-07 nfin=4 $X=10652 $Y=-2024 $D=1
M142 295 14 S1 GND! nmos_rvt L=2e-08 W=1.08e-07 nfin=4 $X=10652 $Y=144 $D=1
M143 297 38 285 GND! nmos_rvt L=2e-08 W=1.08e-07 nfin=4 $X=10868 $Y=-10696 $D=1
M144 299 39 287 GND! nmos_rvt L=2e-08 W=1.08e-07 nfin=4 $X=10868 $Y=-8528 $D=1
M145 301 40 291 GND! nmos_rvt L=2e-08 W=1.08e-07 nfin=4 $X=10868 $Y=-4192 $D=1
M146 303 41 293 GND! nmos_rvt L=2e-08 W=1.08e-07 nfin=4 $X=10868 $Y=-2024 $D=1
M147 305 42 295 GND! nmos_rvt L=2e-08 W=1.08e-07 nfin=4 $X=10868 $Y=144 $D=1
M148 59 55 283 GND! nmos_rvt L=2e-08 W=1.08e-07 nfin=4 $X=11084 $Y=-12864 $D=1
M149 GND! 43 297 GND! nmos_rvt L=2e-08 W=1.08e-07 nfin=4 $X=11084 $Y=-10696 $D=1
M150 GND! 44 299 GND! nmos_rvt L=2e-08 W=1.08e-07 nfin=4 $X=11084 $Y=-8528 $D=1
M151 60 56 289 GND! nmos_rvt L=2e-08 W=1.08e-07 nfin=4 $X=11084 $Y=-6360 $D=1
M152 GND! 45 301 GND! nmos_rvt L=2e-08 W=1.08e-07 nfin=4 $X=11084 $Y=-4192 $D=1
M153 GND! 46 303 GND! nmos_rvt L=2e-08 W=1.08e-07 nfin=4 $X=11084 $Y=-2024 $D=1
M154 GND! 47 305 GND! nmos_rvt L=2e-08 W=1.08e-07 nfin=4 $X=11084 $Y=144 $D=1
M155 307 15 59 GND! nmos_rvt L=2e-08 W=1.08e-07 nfin=4 $X=11300 $Y=-12864 $D=1
M156 308 16 60 GND! nmos_rvt L=2e-08 W=1.08e-07 nfin=4 $X=11300 $Y=-6360 $D=1
M157 GND! 57 307 GND! nmos_rvt L=2e-08 W=1.08e-07 nfin=4 $X=11732 $Y=-12864 $D=1
M158 GND! 58 308 GND! nmos_rvt L=2e-08 W=1.08e-07 nfin=4 $X=11732 $Y=-6360 $D=1
M159 S9 59 GND! GND! nmos_rvt L=2e-08 W=1.08e-07 nfin=4 $X=11948 $Y=-12864 $D=1
M160 S5 60 GND! GND! nmos_rvt L=2e-08 W=1.08e-07 nfin=4 $X=11948 $Y=-6360 $D=1
M161 311 B10 GND! GND! nmos_rvt L=2e-08 W=1.08e-07 nfin=4 $X=12164 $Y=-10696 $D=1
M162 313 B10 GND! GND! nmos_rvt L=2e-08 W=1.08e-07 nfin=4 $X=12164 $Y=-8528 $D=1
M163 315 B6 GND! GND! nmos_rvt L=2e-08 W=1.08e-07 nfin=4 $X=12164 $Y=-4192 $D=1
M164 317 B6 GND! GND! nmos_rvt L=2e-08 W=1.08e-07 nfin=4 $X=12164 $Y=-2024 $D=1
M165 319 B2 GND! GND! nmos_rvt L=2e-08 W=1.08e-07 nfin=4 $X=12164 $Y=144 $D=1
M166 69 A10 311 GND! nmos_rvt L=2e-08 W=1.08e-07 nfin=4 $X=12380 $Y=-10696 $D=1
M167 70 A10 313 GND! nmos_rvt L=2e-08 W=1.08e-07 nfin=4 $X=12380 $Y=-8528 $D=1
M168 71 A6 315 GND! nmos_rvt L=2e-08 W=1.08e-07 nfin=4 $X=12380 $Y=-4192 $D=1
M169 72 A6 317 GND! nmos_rvt L=2e-08 W=1.08e-07 nfin=4 $X=12380 $Y=-2024 $D=1
M170 73 A2 319 GND! nmos_rvt L=2e-08 W=1.08e-07 nfin=4 $X=12380 $Y=144 $D=1
M171 169 48 69 GND! nmos_rvt L=2e-08 W=1.08e-07 nfin=4 $X=12596 $Y=-10696 $D=1
M172 171 49 70 GND! nmos_rvt L=2e-08 W=1.08e-07 nfin=4 $X=12596 $Y=-8528 $D=1
M173 173 50 71 GND! nmos_rvt L=2e-08 W=1.08e-07 nfin=4 $X=12596 $Y=-4192 $D=1
M174 175 51 72 GND! nmos_rvt L=2e-08 W=1.08e-07 nfin=4 $X=12596 $Y=-2024 $D=1
M175 177 52 73 GND! nmos_rvt L=2e-08 W=1.08e-07 nfin=4 $X=12596 $Y=144 $D=1
M176 GND! A10 169 GND! nmos_rvt L=2e-08 W=1.08e-07 nfin=4 $X=12812 $Y=-10696 $D=1
M177 GND! A10 171 GND! nmos_rvt L=2e-08 W=1.08e-07 nfin=4 $X=12812 $Y=-8528 $D=1
M178 GND! A6 173 GND! nmos_rvt L=2e-08 W=1.08e-07 nfin=4 $X=12812 $Y=-4192 $D=1
M179 GND! A6 175 GND! nmos_rvt L=2e-08 W=1.08e-07 nfin=4 $X=12812 $Y=-2024 $D=1
M180 GND! A2 177 GND! nmos_rvt L=2e-08 W=1.08e-07 nfin=4 $X=12812 $Y=144 $D=1
M181 169 B10 GND! GND! nmos_rvt L=2e-08 W=1.08e-07 nfin=4 $X=13028 $Y=-10696 $D=1
M182 171 B10 GND! GND! nmos_rvt L=2e-08 W=1.08e-07 nfin=4 $X=13028 $Y=-8528 $D=1
M183 173 B6 GND! GND! nmos_rvt L=2e-08 W=1.08e-07 nfin=4 $X=13028 $Y=-4192 $D=1
M184 175 B6 GND! GND! nmos_rvt L=2e-08 W=1.08e-07 nfin=4 $X=13028 $Y=-2024 $D=1
M185 177 B2 GND! GND! nmos_rvt L=2e-08 W=1.08e-07 nfin=4 $X=13028 $Y=144 $D=1
M186 36 67 GND! GND! nmos_rvt L=2e-08 W=1.08e-07 nfin=4 $X=13892 $Y=-12864 $D=1
M187 37 68 GND! GND! nmos_rvt L=2e-08 W=1.08e-07 nfin=4 $X=13892 $Y=-6360 $D=1
M188 180 A10 GND! GND! nmos_rvt L=2e-08 W=1.08e-07 nfin=4 $X=14108 $Y=-10696 $D=1
M189 182 A10 GND! GND! nmos_rvt L=2e-08 W=1.08e-07 nfin=4 $X=14108 $Y=-8528 $D=1
M190 184 A6 GND! GND! nmos_rvt L=2e-08 W=1.08e-07 nfin=4 $X=14108 $Y=-4192 $D=1
M191 186 A6 GND! GND! nmos_rvt L=2e-08 W=1.08e-07 nfin=4 $X=14108 $Y=-2024 $D=1
M192 188 A2 GND! GND! nmos_rvt L=2e-08 W=1.08e-07 nfin=4 $X=14108 $Y=144 $D=1
M193 GND! B10 180 GND! nmos_rvt L=2e-08 W=1.08e-07 nfin=4 $X=14324 $Y=-10696 $D=1
M194 GND! B10 182 GND! nmos_rvt L=2e-08 W=1.08e-07 nfin=4 $X=14324 $Y=-8528 $D=1
M195 GND! B6 184 GND! nmos_rvt L=2e-08 W=1.08e-07 nfin=4 $X=14324 $Y=-4192 $D=1
M196 GND! B6 186 GND! nmos_rvt L=2e-08 W=1.08e-07 nfin=4 $X=14324 $Y=-2024 $D=1
M197 GND! B2 188 GND! nmos_rvt L=2e-08 W=1.08e-07 nfin=4 $X=14324 $Y=144 $D=1
M198 180 48 GND! GND! nmos_rvt L=2e-08 W=1.08e-07 nfin=4 $X=14540 $Y=-10696 $D=1
M199 182 49 GND! GND! nmos_rvt L=2e-08 W=1.08e-07 nfin=4 $X=14540 $Y=-8528 $D=1
M200 184 50 GND! GND! nmos_rvt L=2e-08 W=1.08e-07 nfin=4 $X=14540 $Y=-4192 $D=1
M201 186 51 GND! GND! nmos_rvt L=2e-08 W=1.08e-07 nfin=4 $X=14540 $Y=-2024 $D=1
M202 188 52 GND! GND! nmos_rvt L=2e-08 W=1.08e-07 nfin=4 $X=14540 $Y=144 $D=1
M203 78 69 180 GND! nmos_rvt L=2e-08 W=1.08e-07 nfin=4 $X=14756 $Y=-10696 $D=1
M204 79 70 182 GND! nmos_rvt L=2e-08 W=1.08e-07 nfin=4 $X=14756 $Y=-8528 $D=1
M205 80 71 184 GND! nmos_rvt L=2e-08 W=1.08e-07 nfin=4 $X=14756 $Y=-4192 $D=1
M206 81 72 186 GND! nmos_rvt L=2e-08 W=1.08e-07 nfin=4 $X=14756 $Y=-2024 $D=1
M207 82 73 188 GND! nmos_rvt L=2e-08 W=1.08e-07 nfin=4 $X=14756 $Y=144 $D=1
M208 74 36 GND! GND! nmos_rvt L=2e-08 W=1.08e-07 nfin=4 $X=14972 $Y=-12864 $D=1
M209 323 48 78 GND! nmos_rvt L=2e-08 W=1.08e-07 nfin=4 $X=14972 $Y=-10696 $D=1
M210 325 49 79 GND! nmos_rvt L=2e-08 W=1.08e-07 nfin=4 $X=14972 $Y=-8528 $D=1
M211 75 37 GND! GND! nmos_rvt L=2e-08 W=1.08e-07 nfin=4 $X=14972 $Y=-6360 $D=1
M212 327 50 80 GND! nmos_rvt L=2e-08 W=1.08e-07 nfin=4 $X=14972 $Y=-4192 $D=1
M213 329 51 81 GND! nmos_rvt L=2e-08 W=1.08e-07 nfin=4 $X=14972 $Y=-2024 $D=1
M214 331 52 82 GND! nmos_rvt L=2e-08 W=1.08e-07 nfin=4 $X=14972 $Y=144 $D=1
M215 334 B10 323 GND! nmos_rvt L=2e-08 W=1.08e-07 nfin=4 $X=15188 $Y=-10696 $D=1
M216 336 B10 325 GND! nmos_rvt L=2e-08 W=1.08e-07 nfin=4 $X=15188 $Y=-8528 $D=1
M217 339 B6 327 GND! nmos_rvt L=2e-08 W=1.08e-07 nfin=4 $X=15188 $Y=-4192 $D=1
M218 341 B6 329 GND! nmos_rvt L=2e-08 W=1.08e-07 nfin=4 $X=15188 $Y=-2024 $D=1
M219 343 B2 331 GND! nmos_rvt L=2e-08 W=1.08e-07 nfin=4 $X=15188 $Y=144 $D=1
M220 GND! A10 334 GND! nmos_rvt L=2e-08 W=1.08e-07 nfin=4 $X=15404 $Y=-10696 $D=1
M221 GND! A10 336 GND! nmos_rvt L=2e-08 W=1.08e-07 nfin=4 $X=15404 $Y=-8528 $D=1
M222 GND! A6 339 GND! nmos_rvt L=2e-08 W=1.08e-07 nfin=4 $X=15404 $Y=-4192 $D=1
M223 GND! A6 341 GND! nmos_rvt L=2e-08 W=1.08e-07 nfin=4 $X=15404 $Y=-2024 $D=1
M224 GND! A2 343 GND! nmos_rvt L=2e-08 W=1.08e-07 nfin=4 $X=15404 $Y=144 $D=1
M225 GND! 74 83 GND! nmos_rvt L=2e-08 W=1.08e-07 nfin=4 $X=16052 $Y=-12864 $D=1
M226 GND! 75 84 GND! nmos_rvt L=2e-08 W=1.08e-07 nfin=4 $X=16052 $Y=-6360 $D=1
M227 345 76 GND! GND! nmos_rvt L=2e-08 W=1.08e-07 nfin=4 $X=16268 $Y=-12864 $D=1
M228 347 77 GND! GND! nmos_rvt L=2e-08 W=1.08e-07 nfin=4 $X=16268 $Y=-6360 $D=1
M229 85 78 GND! GND! nmos_rvt L=2e-08 W=1.08e-07 nfin=4 $X=16484 $Y=-10696 $D=1
M230 76 79 GND! GND! nmos_rvt L=2e-08 W=1.08e-07 nfin=4 $X=16484 $Y=-8528 $D=1
M231 86 80 GND! GND! nmos_rvt L=2e-08 W=1.08e-07 nfin=4 $X=16484 $Y=-4192 $D=1
M232 77 81 GND! GND! nmos_rvt L=2e-08 W=1.08e-07 nfin=4 $X=16484 $Y=-2024 $D=1
M233 S2 82 GND! GND! nmos_rvt L=2e-08 W=1.08e-07 nfin=4 $X=16484 $Y=144 $D=1
M234 87 83 345 GND! nmos_rvt L=2e-08 W=1.08e-07 nfin=4 $X=16700 $Y=-12864 $D=1
M235 89 84 347 GND! nmos_rvt L=2e-08 W=1.08e-07 nfin=4 $X=16700 $Y=-6360 $D=1
M236 354 74 87 GND! nmos_rvt L=2e-08 W=1.08e-07 nfin=4 $X=16916 $Y=-12864 $D=1
M237 355 75 89 GND! nmos_rvt L=2e-08 W=1.08e-07 nfin=4 $X=16916 $Y=-6360 $D=1
M238 GND! 85 354 GND! nmos_rvt L=2e-08 W=1.08e-07 nfin=4 $X=17348 $Y=-12864 $D=1
M239 GND! 86 355 GND! nmos_rvt L=2e-08 W=1.08e-07 nfin=4 $X=17348 $Y=-6360 $D=1
M240 S10 87 GND! GND! nmos_rvt L=2e-08 W=1.08e-07 nfin=4 $X=17564 $Y=-12864 $D=1
M241 99 B11 GND! GND! nmos_rvt L=2e-08 W=1.08e-07 nfin=4 $X=17564 $Y=-10696 $D=1
M242 100 B11 GND! GND! nmos_rvt L=2e-08 W=1.08e-07 nfin=4 $X=17564 $Y=-8528 $D=1
M243 S6 89 GND! GND! nmos_rvt L=2e-08 W=1.08e-07 nfin=4 $X=17564 $Y=-6360 $D=1
M244 101 B7 GND! GND! nmos_rvt L=2e-08 W=1.08e-07 nfin=4 $X=17564 $Y=-4192 $D=1
M245 102 B7 GND! GND! nmos_rvt L=2e-08 W=1.08e-07 nfin=4 $X=17564 $Y=-2024 $D=1
M246 103 B3 GND! GND! nmos_rvt L=2e-08 W=1.08e-07 nfin=4 $X=17564 $Y=144 $D=1
M247 GND! 74 97 GND! nmos_rvt L=2e-08 W=1.08e-07 nfin=4 $X=18644 $Y=-12864 $D=1
M248 105 A11 GND! GND! nmos_rvt L=2e-08 W=1.08e-07 nfin=4 $X=18644 $Y=-10696 $D=1
M249 106 A11 GND! GND! nmos_rvt L=2e-08 W=1.08e-07 nfin=4 $X=18644 $Y=-8528 $D=1
M250 GND! 75 98 GND! nmos_rvt L=2e-08 W=1.08e-07 nfin=4 $X=18644 $Y=-6360 $D=1
M251 108 A7 GND! GND! nmos_rvt L=2e-08 W=1.08e-07 nfin=4 $X=18644 $Y=-4192 $D=1
M252 109 A7 GND! GND! nmos_rvt L=2e-08 W=1.08e-07 nfin=4 $X=18644 $Y=-2024 $D=1
M253 110 A3 GND! GND! nmos_rvt L=2e-08 W=1.08e-07 nfin=4 $X=18644 $Y=144 $D=1
M254 363 95 GND! GND! nmos_rvt L=2e-08 W=1.08e-07 nfin=4 $X=18860 $Y=-12864 $D=1
M255 367 96 GND! GND! nmos_rvt L=2e-08 W=1.08e-07 nfin=4 $X=18860 $Y=-6360 $D=1
M256 111 97 363 GND! nmos_rvt L=2e-08 W=1.08e-07 nfin=4 $X=19292 $Y=-12864 $D=1
M257 112 98 367 GND! nmos_rvt L=2e-08 W=1.08e-07 nfin=4 $X=19292 $Y=-6360 $D=1
M258 372 74 111 GND! nmos_rvt L=2e-08 W=1.08e-07 nfin=4 $X=19508 $Y=-12864 $D=1
M259 373 75 112 GND! nmos_rvt L=2e-08 W=1.08e-07 nfin=4 $X=19508 $Y=-6360 $D=1
M260 375 99 GND! GND! nmos_rvt L=2e-08 W=1.08e-07 nfin=4 $X=19724 $Y=-10696 $D=1
M261 377 100 GND! GND! nmos_rvt L=2e-08 W=1.08e-07 nfin=4 $X=19724 $Y=-8528 $D=1
M262 380 101 GND! GND! nmos_rvt L=2e-08 W=1.08e-07 nfin=4 $X=19724 $Y=-4192 $D=1
M263 382 102 GND! GND! nmos_rvt L=2e-08 W=1.08e-07 nfin=4 $X=19724 $Y=-2024 $D=1
M264 384 103 GND! GND! nmos_rvt L=2e-08 W=1.08e-07 nfin=4 $X=19724 $Y=144 $D=1
M265 GND! 104 372 GND! nmos_rvt L=2e-08 W=1.08e-07 nfin=4 $X=19940 $Y=-12864 $D=1
M266 104 105 375 GND! nmos_rvt L=2e-08 W=1.08e-07 nfin=4 $X=19940 $Y=-10696 $D=1
M267 95 106 377 GND! nmos_rvt L=2e-08 W=1.08e-07 nfin=4 $X=19940 $Y=-8528 $D=1
M268 GND! 107 373 GND! nmos_rvt L=2e-08 W=1.08e-07 nfin=4 $X=19940 $Y=-6360 $D=1
M269 107 108 380 GND! nmos_rvt L=2e-08 W=1.08e-07 nfin=4 $X=19940 $Y=-4192 $D=1
M270 96 109 382 GND! nmos_rvt L=2e-08 W=1.08e-07 nfin=4 $X=19940 $Y=-2024 $D=1
M271 68 110 384 GND! nmos_rvt L=2e-08 W=1.08e-07 nfin=4 $X=19940 $Y=144 $D=1
M272 121 111 GND! GND! nmos_rvt L=2e-08 W=1.08e-07 nfin=4 $X=20156 $Y=-12864 $D=1
M273 193 69 104 GND! nmos_rvt L=2e-08 W=1.08e-07 nfin=4 $X=20156 $Y=-10696 $D=1
M274 195 70 95 GND! nmos_rvt L=2e-08 W=1.08e-07 nfin=4 $X=20156 $Y=-8528 $D=1
M275 67 112 GND! GND! nmos_rvt L=2e-08 W=1.08e-07 nfin=4 $X=20156 $Y=-6360 $D=1
M276 197 71 107 GND! nmos_rvt L=2e-08 W=1.08e-07 nfin=4 $X=20156 $Y=-4192 $D=1
M277 199 72 96 GND! nmos_rvt L=2e-08 W=1.08e-07 nfin=4 $X=20156 $Y=-2024 $D=1
M278 201 73 68 GND! nmos_rvt L=2e-08 W=1.08e-07 nfin=4 $X=20156 $Y=144 $D=1
M279 GND! 105 193 GND! nmos_rvt L=2e-08 W=1.08e-07 nfin=4 $X=20372 $Y=-10696 $D=1
M280 GND! 106 195 GND! nmos_rvt L=2e-08 W=1.08e-07 nfin=4 $X=20372 $Y=-8528 $D=1
M281 GND! 108 197 GND! nmos_rvt L=2e-08 W=1.08e-07 nfin=4 $X=20372 $Y=-4192 $D=1
M282 GND! 109 199 GND! nmos_rvt L=2e-08 W=1.08e-07 nfin=4 $X=20372 $Y=-2024 $D=1
M283 GND! 110 201 GND! nmos_rvt L=2e-08 W=1.08e-07 nfin=4 $X=20372 $Y=144 $D=1
M284 193 99 GND! GND! nmos_rvt L=2e-08 W=1.08e-07 nfin=4 $X=20588 $Y=-10696 $D=1
M285 195 100 GND! GND! nmos_rvt L=2e-08 W=1.08e-07 nfin=4 $X=20588 $Y=-8528 $D=1
M286 197 101 GND! GND! nmos_rvt L=2e-08 W=1.08e-07 nfin=4 $X=20588 $Y=-4192 $D=1
M287 199 102 GND! GND! nmos_rvt L=2e-08 W=1.08e-07 nfin=4 $X=20588 $Y=-2024 $D=1
M288 201 103 GND! GND! nmos_rvt L=2e-08 W=1.08e-07 nfin=4 $X=20588 $Y=144 $D=1
M289 GND! 74 115 GND! nmos_rvt L=2e-08 W=1.08e-07 nfin=4 $X=21236 $Y=-12864 $D=1
M290 GND! 75 116 GND! nmos_rvt L=2e-08 W=1.08e-07 nfin=4 $X=21236 $Y=-6360 $D=1
M291 386 113 GND! GND! nmos_rvt L=2e-08 W=1.08e-07 nfin=4 $X=21452 $Y=-12864 $D=1
M292 388 114 GND! GND! nmos_rvt L=2e-08 W=1.08e-07 nfin=4 $X=21452 $Y=-6360 $D=1
M293 204 105 GND! GND! nmos_rvt L=2e-08 W=1.08e-07 nfin=4 $X=21668 $Y=-10696 $D=1
M294 206 106 GND! GND! nmos_rvt L=2e-08 W=1.08e-07 nfin=4 $X=21668 $Y=-8528 $D=1
M295 208 108 GND! GND! nmos_rvt L=2e-08 W=1.08e-07 nfin=4 $X=21668 $Y=-4192 $D=1
M296 210 109 GND! GND! nmos_rvt L=2e-08 W=1.08e-07 nfin=4 $X=21668 $Y=-2024 $D=1
M297 212 110 GND! GND! nmos_rvt L=2e-08 W=1.08e-07 nfin=4 $X=21668 $Y=144 $D=1
M298 119 115 386 GND! nmos_rvt L=2e-08 W=1.08e-07 nfin=4 $X=21884 $Y=-12864 $D=1
M299 GND! 99 204 GND! nmos_rvt L=2e-08 W=1.08e-07 nfin=4 $X=21884 $Y=-10696 $D=1
M300 GND! 100 206 GND! nmos_rvt L=2e-08 W=1.08e-07 nfin=4 $X=21884 $Y=-8528 $D=1
M301 120 116 388 GND! nmos_rvt L=2e-08 W=1.08e-07 nfin=4 $X=21884 $Y=-6360 $D=1
M302 GND! 101 208 GND! nmos_rvt L=2e-08 W=1.08e-07 nfin=4 $X=21884 $Y=-4192 $D=1
M303 GND! 102 210 GND! nmos_rvt L=2e-08 W=1.08e-07 nfin=4 $X=21884 $Y=-2024 $D=1
M304 GND! 103 212 GND! nmos_rvt L=2e-08 W=1.08e-07 nfin=4 $X=21884 $Y=144 $D=1
M305 390 74 119 GND! nmos_rvt L=2e-08 W=1.08e-07 nfin=4 $X=22100 $Y=-12864 $D=1
M306 204 69 GND! GND! nmos_rvt L=2e-08 W=1.08e-07 nfin=4 $X=22100 $Y=-10696 $D=1
M307 206 70 GND! GND! nmos_rvt L=2e-08 W=1.08e-07 nfin=4 $X=22100 $Y=-8528 $D=1
M308 391 75 120 GND! nmos_rvt L=2e-08 W=1.08e-07 nfin=4 $X=22100 $Y=-6360 $D=1
M309 208 71 GND! GND! nmos_rvt L=2e-08 W=1.08e-07 nfin=4 $X=22100 $Y=-4192 $D=1
M310 210 72 GND! GND! nmos_rvt L=2e-08 W=1.08e-07 nfin=4 $X=22100 $Y=-2024 $D=1
M311 212 73 GND! GND! nmos_rvt L=2e-08 W=1.08e-07 nfin=4 $X=22100 $Y=144 $D=1
M312 117 104 204 GND! nmos_rvt L=2e-08 W=1.08e-07 nfin=4 $X=22316 $Y=-10696 $D=1
M313 113 95 206 GND! nmos_rvt L=2e-08 W=1.08e-07 nfin=4 $X=22316 $Y=-8528 $D=1
M314 118 107 208 GND! nmos_rvt L=2e-08 W=1.08e-07 nfin=4 $X=22316 $Y=-4192 $D=1
M315 114 96 210 GND! nmos_rvt L=2e-08 W=1.08e-07 nfin=4 $X=22316 $Y=-2024 $D=1
M316 S3 68 212 GND! nmos_rvt L=2e-08 W=1.08e-07 nfin=4 $X=22316 $Y=144 $D=1
M317 GND! 117 390 GND! nmos_rvt L=2e-08 W=1.08e-07 nfin=4 $X=22532 $Y=-12864 $D=1
M318 394 69 117 GND! nmos_rvt L=2e-08 W=1.08e-07 nfin=4 $X=22532 $Y=-10696 $D=1
M319 396 70 113 GND! nmos_rvt L=2e-08 W=1.08e-07 nfin=4 $X=22532 $Y=-8528 $D=1
M320 GND! 118 391 GND! nmos_rvt L=2e-08 W=1.08e-07 nfin=4 $X=22532 $Y=-6360 $D=1
M321 398 71 118 GND! nmos_rvt L=2e-08 W=1.08e-07 nfin=4 $X=22532 $Y=-4192 $D=1
M322 400 72 114 GND! nmos_rvt L=2e-08 W=1.08e-07 nfin=4 $X=22532 $Y=-2024 $D=1
M323 402 73 S3 GND! nmos_rvt L=2e-08 W=1.08e-07 nfin=4 $X=22532 $Y=144 $D=1
M324 S11 119 GND! GND! nmos_rvt L=2e-08 W=1.08e-07 nfin=4 $X=22748 $Y=-12864 $D=1
M325 404 99 394 GND! nmos_rvt L=2e-08 W=1.08e-07 nfin=4 $X=22748 $Y=-10696 $D=1
M326 406 100 396 GND! nmos_rvt L=2e-08 W=1.08e-07 nfin=4 $X=22748 $Y=-8528 $D=1
M327 S7 120 GND! GND! nmos_rvt L=2e-08 W=1.08e-07 nfin=4 $X=22748 $Y=-6360 $D=1
M328 408 101 398 GND! nmos_rvt L=2e-08 W=1.08e-07 nfin=4 $X=22748 $Y=-4192 $D=1
M329 410 102 400 GND! nmos_rvt L=2e-08 W=1.08e-07 nfin=4 $X=22748 $Y=-2024 $D=1
M330 412 103 402 GND! nmos_rvt L=2e-08 W=1.08e-07 nfin=4 $X=22748 $Y=144 $D=1
M331 GND! 105 404 GND! nmos_rvt L=2e-08 W=1.08e-07 nfin=4 $X=22964 $Y=-10696 $D=1
M332 GND! 106 406 GND! nmos_rvt L=2e-08 W=1.08e-07 nfin=4 $X=22964 $Y=-8528 $D=1
M333 GND! 108 408 GND! nmos_rvt L=2e-08 W=1.08e-07 nfin=4 $X=22964 $Y=-4192 $D=1
M334 GND! 109 410 GND! nmos_rvt L=2e-08 W=1.08e-07 nfin=4 $X=22964 $Y=-2024 $D=1
M335 GND! 110 412 GND! nmos_rvt L=2e-08 W=1.08e-07 nfin=4 $X=22964 $Y=144 $D=1
M336 414 121 GND! GND! nmos_rvt L=2e-08 W=1.08e-07 nfin=4 $X=23828 $Y=-12864 $D=1
M337 S12 122 GND! GND! nmos_rvt L=2e-08 W=1.08e-07 nfin=4 $X=23828 $Y=-6360 $D=1
M338 122 121 414 GND! nmos_rvt L=2e-08 W=1.08e-07 nfin=4 $X=24044 $Y=-12864 $D=1
M339 GND! 122 S12 GND! nmos_rvt L=2e-08 W=1.08e-07 nfin=4 $X=24044 $Y=-6360 $D=1
M340 219 B8 VDD! VDD! pmos_rvt L=2e-08 W=1.08e-07 nfin=4 $X=284 $Y=-10048 $D=0
M341 221 B8 VDD! VDD! pmos_rvt L=2e-08 W=1.08e-07 nfin=4 $X=284 $Y=-7880 $D=0
M342 223 B4 VDD! VDD! pmos_rvt L=2e-08 W=1.08e-07 nfin=4 $X=284 $Y=-3544 $D=0
M343 225 B4 VDD! VDD! pmos_rvt L=2e-08 W=1.08e-07 nfin=4 $X=284 $Y=-1376 $D=0
M344 227 B0 VDD! VDD! pmos_rvt L=2e-08 W=1.08e-07 nfin=4 $X=284 $Y=792 $D=0
M345 10 A8 219 VDD! pmos_rvt L=2e-08 W=1.08e-07 nfin=4 $X=500 $Y=-10048 $D=0
M346 11 A8 221 VDD! pmos_rvt L=2e-08 W=1.08e-07 nfin=4 $X=500 $Y=-7880 $D=0
M347 12 A4 223 VDD! pmos_rvt L=2e-08 W=1.08e-07 nfin=4 $X=500 $Y=-3544 $D=0
M348 13 A4 225 VDD! pmos_rvt L=2e-08 W=1.08e-07 nfin=4 $X=500 $Y=-1376 $D=0
M349 14 A0 227 VDD! pmos_rvt L=2e-08 W=1.08e-07 nfin=4 $X=500 $Y=792 $D=0
M350 124 VDD! 10 VDD! pmos_rvt L=2e-08 W=1.08e-07 nfin=4 $X=716 $Y=-10048 $D=0
M351 126 GND! 11 VDD! pmos_rvt L=2e-08 W=1.08e-07 nfin=4 $X=716 $Y=-7880 $D=0
M352 128 VDD! 12 VDD! pmos_rvt L=2e-08 W=1.08e-07 nfin=4 $X=716 $Y=-3544 $D=0
M353 130 GND! 13 VDD! pmos_rvt L=2e-08 W=1.08e-07 nfin=4 $X=716 $Y=-1376 $D=0
M354 132 CARRY 14 VDD! pmos_rvt L=2e-08 W=1.08e-07 nfin=4 $X=716 $Y=792 $D=0
M355 VDD! A8 124 VDD! pmos_rvt L=2e-08 W=1.08e-07 nfin=4 $X=932 $Y=-10048 $D=0
M356 VDD! A8 126 VDD! pmos_rvt L=2e-08 W=1.08e-07 nfin=4 $X=932 $Y=-7880 $D=0
M357 VDD! A4 128 VDD! pmos_rvt L=2e-08 W=1.08e-07 nfin=4 $X=932 $Y=-3544 $D=0
M358 VDD! A4 130 VDD! pmos_rvt L=2e-08 W=1.08e-07 nfin=4 $X=932 $Y=-1376 $D=0
M359 VDD! A0 132 VDD! pmos_rvt L=2e-08 W=1.08e-07 nfin=4 $X=932 $Y=792 $D=0
M360 124 B8 VDD! VDD! pmos_rvt L=2e-08 W=1.08e-07 nfin=4 $X=1148 $Y=-10048 $D=0
M361 126 B8 VDD! VDD! pmos_rvt L=2e-08 W=1.08e-07 nfin=4 $X=1148 $Y=-7880 $D=0
M362 128 B4 VDD! VDD! pmos_rvt L=2e-08 W=1.08e-07 nfin=4 $X=1148 $Y=-3544 $D=0
M363 130 B4 VDD! VDD! pmos_rvt L=2e-08 W=1.08e-07 nfin=4 $X=1148 $Y=-1376 $D=0
M364 132 B0 VDD! VDD! pmos_rvt L=2e-08 W=1.08e-07 nfin=4 $X=1148 $Y=792 $D=0
M365 134 A8 VDD! VDD! pmos_rvt L=2e-08 W=1.08e-07 nfin=4 $X=2228 $Y=-10048 $D=0
M366 136 A8 VDD! VDD! pmos_rvt L=2e-08 W=1.08e-07 nfin=4 $X=2228 $Y=-7880 $D=0
M367 138 A4 VDD! VDD! pmos_rvt L=2e-08 W=1.08e-07 nfin=4 $X=2228 $Y=-3544 $D=0
M368 140 A4 VDD! VDD! pmos_rvt L=2e-08 W=1.08e-07 nfin=4 $X=2228 $Y=-1376 $D=0
M369 142 A0 VDD! VDD! pmos_rvt L=2e-08 W=1.08e-07 nfin=4 $X=2228 $Y=792 $D=0
M370 VDD! B8 134 VDD! pmos_rvt L=2e-08 W=1.08e-07 nfin=4 $X=2444 $Y=-10048 $D=0
M371 VDD! B8 136 VDD! pmos_rvt L=2e-08 W=1.08e-07 nfin=4 $X=2444 $Y=-7880 $D=0
M372 VDD! B4 138 VDD! pmos_rvt L=2e-08 W=1.08e-07 nfin=4 $X=2444 $Y=-3544 $D=0
M373 VDD! B4 140 VDD! pmos_rvt L=2e-08 W=1.08e-07 nfin=4 $X=2444 $Y=-1376 $D=0
M374 VDD! B0 142 VDD! pmos_rvt L=2e-08 W=1.08e-07 nfin=4 $X=2444 $Y=792 $D=0
M375 134 VDD! VDD! VDD! pmos_rvt L=2e-08 W=1.08e-07 nfin=4 $X=2660 $Y=-10048 $D=0
M376 136 GND! VDD! VDD! pmos_rvt L=2e-08 W=1.08e-07 nfin=4 $X=2660 $Y=-7880 $D=0
M377 138 VDD! VDD! VDD! pmos_rvt L=2e-08 W=1.08e-07 nfin=4 $X=2660 $Y=-3544 $D=0
M378 140 GND! VDD! VDD! pmos_rvt L=2e-08 W=1.08e-07 nfin=4 $X=2660 $Y=-1376 $D=0
M379 142 CARRY VDD! VDD! pmos_rvt L=2e-08 W=1.08e-07 nfin=4 $X=2660 $Y=792 $D=0
M380 19 10 134 VDD! pmos_rvt L=2e-08 W=1.08e-07 nfin=4 $X=2876 $Y=-10048 $D=0
M381 20 11 136 VDD! pmos_rvt L=2e-08 W=1.08e-07 nfin=4 $X=2876 $Y=-7880 $D=0
M382 21 12 138 VDD! pmos_rvt L=2e-08 W=1.08e-07 nfin=4 $X=2876 $Y=-3544 $D=0
M383 22 13 140 VDD! pmos_rvt L=2e-08 W=1.08e-07 nfin=4 $X=2876 $Y=-1376 $D=0
M384 23 14 142 VDD! pmos_rvt L=2e-08 W=1.08e-07 nfin=4 $X=2876 $Y=792 $D=0
M385 229 VDD! 19 VDD! pmos_rvt L=2e-08 W=1.08e-07 nfin=4 $X=3092 $Y=-10048 $D=0
M386 231 GND! 20 VDD! pmos_rvt L=2e-08 W=1.08e-07 nfin=4 $X=3092 $Y=-7880 $D=0
M387 233 VDD! 21 VDD! pmos_rvt L=2e-08 W=1.08e-07 nfin=4 $X=3092 $Y=-3544 $D=0
M388 235 GND! 22 VDD! pmos_rvt L=2e-08 W=1.08e-07 nfin=4 $X=3092 $Y=-1376 $D=0
M389 237 CARRY 23 VDD! pmos_rvt L=2e-08 W=1.08e-07 nfin=4 $X=3092 $Y=792 $D=0
M390 239 B8 229 VDD! pmos_rvt L=2e-08 W=1.08e-07 nfin=4 $X=3308 $Y=-10048 $D=0
M391 241 B8 231 VDD! pmos_rvt L=2e-08 W=1.08e-07 nfin=4 $X=3308 $Y=-7880 $D=0
M392 243 B4 233 VDD! pmos_rvt L=2e-08 W=1.08e-07 nfin=4 $X=3308 $Y=-3544 $D=0
M393 245 B4 235 VDD! pmos_rvt L=2e-08 W=1.08e-07 nfin=4 $X=3308 $Y=-1376 $D=0
M394 247 B0 237 VDD! pmos_rvt L=2e-08 W=1.08e-07 nfin=4 $X=3308 $Y=792 $D=0
M395 VDD! A8 239 VDD! pmos_rvt L=2e-08 W=1.08e-07 nfin=4 $X=3524 $Y=-10048 $D=0
M396 VDD! A8 241 VDD! pmos_rvt L=2e-08 W=1.08e-07 nfin=4 $X=3524 $Y=-7880 $D=0
M397 VDD! A4 243 VDD! pmos_rvt L=2e-08 W=1.08e-07 nfin=4 $X=3524 $Y=-3544 $D=0
M398 VDD! A4 245 VDD! pmos_rvt L=2e-08 W=1.08e-07 nfin=4 $X=3524 $Y=-1376 $D=0
M399 VDD! A0 247 VDD! pmos_rvt L=2e-08 W=1.08e-07 nfin=4 $X=3524 $Y=792 $D=0
M400 VDD! 15 24 VDD! pmos_rvt L=2e-08 W=1.08e-07 nfin=4 $X=4172 $Y=-12216 $D=0
M401 VDD! 16 25 VDD! pmos_rvt L=2e-08 W=1.08e-07 nfin=4 $X=4172 $Y=-5712 $D=0
M402 249 17 VDD! VDD! pmos_rvt L=2e-08 W=1.08e-07 nfin=4 $X=4388 $Y=-12216 $D=0
M403 251 18 VDD! VDD! pmos_rvt L=2e-08 W=1.08e-07 nfin=4 $X=4388 $Y=-5712 $D=0
M404 28 15 249 VDD! pmos_rvt L=2e-08 W=1.08e-07 nfin=4 $X=4604 $Y=-12216 $D=0
M405 26 19 VDD! VDD! pmos_rvt L=2e-08 W=1.08e-07 nfin=4 $X=4604 $Y=-10048 $D=0
M406 17 20 VDD! VDD! pmos_rvt L=2e-08 W=1.08e-07 nfin=4 $X=4604 $Y=-7880 $D=0
M407 30 16 251 VDD! pmos_rvt L=2e-08 W=1.08e-07 nfin=4 $X=4604 $Y=-5712 $D=0
M408 27 21 VDD! VDD! pmos_rvt L=2e-08 W=1.08e-07 nfin=4 $X=4604 $Y=-3544 $D=0
M409 18 22 VDD! VDD! pmos_rvt L=2e-08 W=1.08e-07 nfin=4 $X=4604 $Y=-1376 $D=0
M410 S0 23 VDD! VDD! pmos_rvt L=2e-08 W=1.08e-07 nfin=4 $X=4604 $Y=792 $D=0
M411 259 24 28 VDD! pmos_rvt L=2e-08 W=1.08e-07 nfin=4 $X=5252 $Y=-12216 $D=0
M412 260 25 30 VDD! pmos_rvt L=2e-08 W=1.08e-07 nfin=4 $X=5252 $Y=-5712 $D=0
M413 VDD! 26 259 VDD! pmos_rvt L=2e-08 W=1.08e-07 nfin=4 $X=5468 $Y=-12216 $D=0
M414 VDD! 27 260 VDD! pmos_rvt L=2e-08 W=1.08e-07 nfin=4 $X=5468 $Y=-5712 $D=0
M415 S8 28 VDD! VDD! pmos_rvt L=2e-08 W=1.08e-07 nfin=4 $X=5684 $Y=-12216 $D=0
M416 38 B9 VDD! VDD! pmos_rvt L=2e-08 W=1.08e-07 nfin=4 $X=5684 $Y=-10048 $D=0
M417 39 B9 VDD! VDD! pmos_rvt L=2e-08 W=1.08e-07 nfin=4 $X=5684 $Y=-7880 $D=0
M418 S4 30 VDD! VDD! pmos_rvt L=2e-08 W=1.08e-07 nfin=4 $X=5684 $Y=-5712 $D=0
M419 40 B5 VDD! VDD! pmos_rvt L=2e-08 W=1.08e-07 nfin=4 $X=5684 $Y=-3544 $D=0
M420 41 B5 VDD! VDD! pmos_rvt L=2e-08 W=1.08e-07 nfin=4 $X=5684 $Y=-1376 $D=0
M421 42 B1 VDD! VDD! pmos_rvt L=2e-08 W=1.08e-07 nfin=4 $X=5684 $Y=792 $D=0
M422 43 A9 VDD! VDD! pmos_rvt L=2e-08 W=1.08e-07 nfin=4 $X=6764 $Y=-10048 $D=0
M423 44 A9 VDD! VDD! pmos_rvt L=2e-08 W=1.08e-07 nfin=4 $X=6764 $Y=-7880 $D=0
M424 45 A5 VDD! VDD! pmos_rvt L=2e-08 W=1.08e-07 nfin=4 $X=6764 $Y=-3544 $D=0
M425 46 A5 VDD! VDD! pmos_rvt L=2e-08 W=1.08e-07 nfin=4 $X=6764 $Y=-1376 $D=0
M426 47 A1 VDD! VDD! pmos_rvt L=2e-08 W=1.08e-07 nfin=4 $X=6764 $Y=792 $D=0
M427 15 36 VDD! VDD! pmos_rvt L=2e-08 W=1.08e-07 nfin=4 $X=7196 $Y=-12216 $D=0
M428 16 37 VDD! VDD! pmos_rvt L=2e-08 W=1.08e-07 nfin=4 $X=7196 $Y=-5712 $D=0
M429 274 38 VDD! VDD! pmos_rvt L=2e-08 W=1.08e-07 nfin=4 $X=7844 $Y=-10048 $D=0
M430 276 39 VDD! VDD! pmos_rvt L=2e-08 W=1.08e-07 nfin=4 $X=7844 $Y=-7880 $D=0
M431 278 40 VDD! VDD! pmos_rvt L=2e-08 W=1.08e-07 nfin=4 $X=7844 $Y=-3544 $D=0
M432 280 41 VDD! VDD! pmos_rvt L=2e-08 W=1.08e-07 nfin=4 $X=7844 $Y=-1376 $D=0
M433 282 42 VDD! VDD! pmos_rvt L=2e-08 W=1.08e-07 nfin=4 $X=7844 $Y=792 $D=0
M434 48 43 274 VDD! pmos_rvt L=2e-08 W=1.08e-07 nfin=4 $X=8060 $Y=-10048 $D=0
M435 49 44 276 VDD! pmos_rvt L=2e-08 W=1.08e-07 nfin=4 $X=8060 $Y=-7880 $D=0
M436 50 45 278 VDD! pmos_rvt L=2e-08 W=1.08e-07 nfin=4 $X=8060 $Y=-3544 $D=0
M437 51 46 280 VDD! pmos_rvt L=2e-08 W=1.08e-07 nfin=4 $X=8060 $Y=-1376 $D=0
M438 52 47 282 VDD! pmos_rvt L=2e-08 W=1.08e-07 nfin=4 $X=8060 $Y=792 $D=0
M439 147 10 48 VDD! pmos_rvt L=2e-08 W=1.08e-07 nfin=4 $X=8276 $Y=-10048 $D=0
M440 149 11 49 VDD! pmos_rvt L=2e-08 W=1.08e-07 nfin=4 $X=8276 $Y=-7880 $D=0
M441 151 12 50 VDD! pmos_rvt L=2e-08 W=1.08e-07 nfin=4 $X=8276 $Y=-3544 $D=0
M442 153 13 51 VDD! pmos_rvt L=2e-08 W=1.08e-07 nfin=4 $X=8276 $Y=-1376 $D=0
M443 155 14 52 VDD! pmos_rvt L=2e-08 W=1.08e-07 nfin=4 $X=8276 $Y=792 $D=0
M444 VDD! 43 147 VDD! pmos_rvt L=2e-08 W=1.08e-07 nfin=4 $X=8492 $Y=-10048 $D=0
M445 VDD! 44 149 VDD! pmos_rvt L=2e-08 W=1.08e-07 nfin=4 $X=8492 $Y=-7880 $D=0
M446 VDD! 45 151 VDD! pmos_rvt L=2e-08 W=1.08e-07 nfin=4 $X=8492 $Y=-3544 $D=0
M447 VDD! 46 153 VDD! pmos_rvt L=2e-08 W=1.08e-07 nfin=4 $X=8492 $Y=-1376 $D=0
M448 VDD! 47 155 VDD! pmos_rvt L=2e-08 W=1.08e-07 nfin=4 $X=8492 $Y=792 $D=0
M449 147 38 VDD! VDD! pmos_rvt L=2e-08 W=1.08e-07 nfin=4 $X=8708 $Y=-10048 $D=0
M450 149 39 VDD! VDD! pmos_rvt L=2e-08 W=1.08e-07 nfin=4 $X=8708 $Y=-7880 $D=0
M451 151 40 VDD! VDD! pmos_rvt L=2e-08 W=1.08e-07 nfin=4 $X=8708 $Y=-3544 $D=0
M452 153 41 VDD! VDD! pmos_rvt L=2e-08 W=1.08e-07 nfin=4 $X=8708 $Y=-1376 $D=0
M453 155 42 VDD! VDD! pmos_rvt L=2e-08 W=1.08e-07 nfin=4 $X=8708 $Y=792 $D=0
M454 157 43 VDD! VDD! pmos_rvt L=2e-08 W=1.08e-07 nfin=4 $X=9788 $Y=-10048 $D=0
M455 159 44 VDD! VDD! pmos_rvt L=2e-08 W=1.08e-07 nfin=4 $X=9788 $Y=-7880 $D=0
M456 161 45 VDD! VDD! pmos_rvt L=2e-08 W=1.08e-07 nfin=4 $X=9788 $Y=-3544 $D=0
M457 163 46 VDD! VDD! pmos_rvt L=2e-08 W=1.08e-07 nfin=4 $X=9788 $Y=-1376 $D=0
M458 165 47 VDD! VDD! pmos_rvt L=2e-08 W=1.08e-07 nfin=4 $X=9788 $Y=792 $D=0
M459 VDD! 38 157 VDD! pmos_rvt L=2e-08 W=1.08e-07 nfin=4 $X=10004 $Y=-10048 $D=0
M460 VDD! 39 159 VDD! pmos_rvt L=2e-08 W=1.08e-07 nfin=4 $X=10004 $Y=-7880 $D=0
M461 VDD! 40 161 VDD! pmos_rvt L=2e-08 W=1.08e-07 nfin=4 $X=10004 $Y=-3544 $D=0
M462 VDD! 41 163 VDD! pmos_rvt L=2e-08 W=1.08e-07 nfin=4 $X=10004 $Y=-1376 $D=0
M463 VDD! 42 165 VDD! pmos_rvt L=2e-08 W=1.08e-07 nfin=4 $X=10004 $Y=792 $D=0
M464 157 10 VDD! VDD! pmos_rvt L=2e-08 W=1.08e-07 nfin=4 $X=10220 $Y=-10048 $D=0
M465 159 11 VDD! VDD! pmos_rvt L=2e-08 W=1.08e-07 nfin=4 $X=10220 $Y=-7880 $D=0
M466 161 12 VDD! VDD! pmos_rvt L=2e-08 W=1.08e-07 nfin=4 $X=10220 $Y=-3544 $D=0
M467 163 13 VDD! VDD! pmos_rvt L=2e-08 W=1.08e-07 nfin=4 $X=10220 $Y=-1376 $D=0
M468 165 14 VDD! VDD! pmos_rvt L=2e-08 W=1.08e-07 nfin=4 $X=10220 $Y=792 $D=0
M469 VDD! 15 55 VDD! pmos_rvt L=2e-08 W=1.08e-07 nfin=4 $X=10436 $Y=-12216 $D=0
M470 57 48 157 VDD! pmos_rvt L=2e-08 W=1.08e-07 nfin=4 $X=10436 $Y=-10048 $D=0
M471 53 49 159 VDD! pmos_rvt L=2e-08 W=1.08e-07 nfin=4 $X=10436 $Y=-7880 $D=0
M472 VDD! 16 56 VDD! pmos_rvt L=2e-08 W=1.08e-07 nfin=4 $X=10436 $Y=-5712 $D=0
M473 58 50 161 VDD! pmos_rvt L=2e-08 W=1.08e-07 nfin=4 $X=10436 $Y=-3544 $D=0
M474 54 51 163 VDD! pmos_rvt L=2e-08 W=1.08e-07 nfin=4 $X=10436 $Y=-1376 $D=0
M475 S1 52 165 VDD! pmos_rvt L=2e-08 W=1.08e-07 nfin=4 $X=10436 $Y=792 $D=0
M476 284 53 VDD! VDD! pmos_rvt L=2e-08 W=1.08e-07 nfin=4 $X=10652 $Y=-12216 $D=0
M477 286 10 57 VDD! pmos_rvt L=2e-08 W=1.08e-07 nfin=4 $X=10652 $Y=-10048 $D=0
M478 288 11 53 VDD! pmos_rvt L=2e-08 W=1.08e-07 nfin=4 $X=10652 $Y=-7880 $D=0
M479 290 54 VDD! VDD! pmos_rvt L=2e-08 W=1.08e-07 nfin=4 $X=10652 $Y=-5712 $D=0
M480 292 12 58 VDD! pmos_rvt L=2e-08 W=1.08e-07 nfin=4 $X=10652 $Y=-3544 $D=0
M481 294 13 54 VDD! pmos_rvt L=2e-08 W=1.08e-07 nfin=4 $X=10652 $Y=-1376 $D=0
M482 296 14 S1 VDD! pmos_rvt L=2e-08 W=1.08e-07 nfin=4 $X=10652 $Y=792 $D=0
M483 59 15 284 VDD! pmos_rvt L=2e-08 W=1.08e-07 nfin=4 $X=10868 $Y=-12216 $D=0
M484 298 38 286 VDD! pmos_rvt L=2e-08 W=1.08e-07 nfin=4 $X=10868 $Y=-10048 $D=0
M485 300 39 288 VDD! pmos_rvt L=2e-08 W=1.08e-07 nfin=4 $X=10868 $Y=-7880 $D=0
M486 60 16 290 VDD! pmos_rvt L=2e-08 W=1.08e-07 nfin=4 $X=10868 $Y=-5712 $D=0
M487 302 40 292 VDD! pmos_rvt L=2e-08 W=1.08e-07 nfin=4 $X=10868 $Y=-3544 $D=0
M488 304 41 294 VDD! pmos_rvt L=2e-08 W=1.08e-07 nfin=4 $X=10868 $Y=-1376 $D=0
M489 306 42 296 VDD! pmos_rvt L=2e-08 W=1.08e-07 nfin=4 $X=10868 $Y=792 $D=0
M490 VDD! 43 298 VDD! pmos_rvt L=2e-08 W=1.08e-07 nfin=4 $X=11084 $Y=-10048 $D=0
M491 VDD! 44 300 VDD! pmos_rvt L=2e-08 W=1.08e-07 nfin=4 $X=11084 $Y=-7880 $D=0
M492 VDD! 45 302 VDD! pmos_rvt L=2e-08 W=1.08e-07 nfin=4 $X=11084 $Y=-3544 $D=0
M493 VDD! 46 304 VDD! pmos_rvt L=2e-08 W=1.08e-07 nfin=4 $X=11084 $Y=-1376 $D=0
M494 VDD! 47 306 VDD! pmos_rvt L=2e-08 W=1.08e-07 nfin=4 $X=11084 $Y=792 $D=0
M495 309 55 59 VDD! pmos_rvt L=2e-08 W=1.08e-07 nfin=4 $X=11516 $Y=-12216 $D=0
M496 310 56 60 VDD! pmos_rvt L=2e-08 W=1.08e-07 nfin=4 $X=11516 $Y=-5712 $D=0
M497 VDD! 57 309 VDD! pmos_rvt L=2e-08 W=1.08e-07 nfin=4 $X=11732 $Y=-12216 $D=0
M498 VDD! 58 310 VDD! pmos_rvt L=2e-08 W=1.08e-07 nfin=4 $X=11732 $Y=-5712 $D=0
M499 S9 59 VDD! VDD! pmos_rvt L=2e-08 W=1.08e-07 nfin=4 $X=11948 $Y=-12216 $D=0
M500 S5 60 VDD! VDD! pmos_rvt L=2e-08 W=1.08e-07 nfin=4 $X=11948 $Y=-5712 $D=0
M501 312 B10 VDD! VDD! pmos_rvt L=2e-08 W=1.08e-07 nfin=4 $X=12164 $Y=-10048 $D=0
M502 314 B10 VDD! VDD! pmos_rvt L=2e-08 W=1.08e-07 nfin=4 $X=12164 $Y=-7880 $D=0
M503 316 B6 VDD! VDD! pmos_rvt L=2e-08 W=1.08e-07 nfin=4 $X=12164 $Y=-3544 $D=0
M504 318 B6 VDD! VDD! pmos_rvt L=2e-08 W=1.08e-07 nfin=4 $X=12164 $Y=-1376 $D=0
M505 320 B2 VDD! VDD! pmos_rvt L=2e-08 W=1.08e-07 nfin=4 $X=12164 $Y=792 $D=0
M506 69 A10 312 VDD! pmos_rvt L=2e-08 W=1.08e-07 nfin=4 $X=12380 $Y=-10048 $D=0
M507 70 A10 314 VDD! pmos_rvt L=2e-08 W=1.08e-07 nfin=4 $X=12380 $Y=-7880 $D=0
M508 71 A6 316 VDD! pmos_rvt L=2e-08 W=1.08e-07 nfin=4 $X=12380 $Y=-3544 $D=0
M509 72 A6 318 VDD! pmos_rvt L=2e-08 W=1.08e-07 nfin=4 $X=12380 $Y=-1376 $D=0
M510 73 A2 320 VDD! pmos_rvt L=2e-08 W=1.08e-07 nfin=4 $X=12380 $Y=792 $D=0
M511 170 48 69 VDD! pmos_rvt L=2e-08 W=1.08e-07 nfin=4 $X=12596 $Y=-10048 $D=0
M512 172 49 70 VDD! pmos_rvt L=2e-08 W=1.08e-07 nfin=4 $X=12596 $Y=-7880 $D=0
M513 174 50 71 VDD! pmos_rvt L=2e-08 W=1.08e-07 nfin=4 $X=12596 $Y=-3544 $D=0
M514 176 51 72 VDD! pmos_rvt L=2e-08 W=1.08e-07 nfin=4 $X=12596 $Y=-1376 $D=0
M515 178 52 73 VDD! pmos_rvt L=2e-08 W=1.08e-07 nfin=4 $X=12596 $Y=792 $D=0
M516 VDD! A10 170 VDD! pmos_rvt L=2e-08 W=1.08e-07 nfin=4 $X=12812 $Y=-10048 $D=0
M517 VDD! A10 172 VDD! pmos_rvt L=2e-08 W=1.08e-07 nfin=4 $X=12812 $Y=-7880 $D=0
M518 VDD! A6 174 VDD! pmos_rvt L=2e-08 W=1.08e-07 nfin=4 $X=12812 $Y=-3544 $D=0
M519 VDD! A6 176 VDD! pmos_rvt L=2e-08 W=1.08e-07 nfin=4 $X=12812 $Y=-1376 $D=0
M520 VDD! A2 178 VDD! pmos_rvt L=2e-08 W=1.08e-07 nfin=4 $X=12812 $Y=792 $D=0
M521 170 B10 VDD! VDD! pmos_rvt L=2e-08 W=1.08e-07 nfin=4 $X=13028 $Y=-10048 $D=0
M522 172 B10 VDD! VDD! pmos_rvt L=2e-08 W=1.08e-07 nfin=4 $X=13028 $Y=-7880 $D=0
M523 174 B6 VDD! VDD! pmos_rvt L=2e-08 W=1.08e-07 nfin=4 $X=13028 $Y=-3544 $D=0
M524 176 B6 VDD! VDD! pmos_rvt L=2e-08 W=1.08e-07 nfin=4 $X=13028 $Y=-1376 $D=0
M525 178 B2 VDD! VDD! pmos_rvt L=2e-08 W=1.08e-07 nfin=4 $X=13028 $Y=792 $D=0
M526 36 67 VDD! VDD! pmos_rvt L=2e-08 W=1.08e-07 nfin=4 $X=13892 $Y=-12216 $D=0
M527 37 68 VDD! VDD! pmos_rvt L=2e-08 W=1.08e-07 nfin=4 $X=13892 $Y=-5712 $D=0
M528 181 A10 VDD! VDD! pmos_rvt L=2e-08 W=1.08e-07 nfin=4 $X=14108 $Y=-10048 $D=0
M529 183 A10 VDD! VDD! pmos_rvt L=2e-08 W=1.08e-07 nfin=4 $X=14108 $Y=-7880 $D=0
M530 185 A6 VDD! VDD! pmos_rvt L=2e-08 W=1.08e-07 nfin=4 $X=14108 $Y=-3544 $D=0
M531 187 A6 VDD! VDD! pmos_rvt L=2e-08 W=1.08e-07 nfin=4 $X=14108 $Y=-1376 $D=0
M532 189 A2 VDD! VDD! pmos_rvt L=2e-08 W=1.08e-07 nfin=4 $X=14108 $Y=792 $D=0
M533 VDD! B10 181 VDD! pmos_rvt L=2e-08 W=1.08e-07 nfin=4 $X=14324 $Y=-10048 $D=0
M534 VDD! B10 183 VDD! pmos_rvt L=2e-08 W=1.08e-07 nfin=4 $X=14324 $Y=-7880 $D=0
M535 VDD! B6 185 VDD! pmos_rvt L=2e-08 W=1.08e-07 nfin=4 $X=14324 $Y=-3544 $D=0
M536 VDD! B6 187 VDD! pmos_rvt L=2e-08 W=1.08e-07 nfin=4 $X=14324 $Y=-1376 $D=0
M537 VDD! B2 189 VDD! pmos_rvt L=2e-08 W=1.08e-07 nfin=4 $X=14324 $Y=792 $D=0
M538 181 48 VDD! VDD! pmos_rvt L=2e-08 W=1.08e-07 nfin=4 $X=14540 $Y=-10048 $D=0
M539 183 49 VDD! VDD! pmos_rvt L=2e-08 W=1.08e-07 nfin=4 $X=14540 $Y=-7880 $D=0
M540 185 50 VDD! VDD! pmos_rvt L=2e-08 W=1.08e-07 nfin=4 $X=14540 $Y=-3544 $D=0
M541 187 51 VDD! VDD! pmos_rvt L=2e-08 W=1.08e-07 nfin=4 $X=14540 $Y=-1376 $D=0
M542 189 52 VDD! VDD! pmos_rvt L=2e-08 W=1.08e-07 nfin=4 $X=14540 $Y=792 $D=0
M543 78 69 181 VDD! pmos_rvt L=2e-08 W=1.08e-07 nfin=4 $X=14756 $Y=-10048 $D=0
M544 79 70 183 VDD! pmos_rvt L=2e-08 W=1.08e-07 nfin=4 $X=14756 $Y=-7880 $D=0
M545 80 71 185 VDD! pmos_rvt L=2e-08 W=1.08e-07 nfin=4 $X=14756 $Y=-3544 $D=0
M546 81 72 187 VDD! pmos_rvt L=2e-08 W=1.08e-07 nfin=4 $X=14756 $Y=-1376 $D=0
M547 82 73 189 VDD! pmos_rvt L=2e-08 W=1.08e-07 nfin=4 $X=14756 $Y=792 $D=0
M548 74 36 VDD! VDD! pmos_rvt L=2e-08 W=1.08e-07 nfin=4 $X=14972 $Y=-12216 $D=0
M549 324 48 78 VDD! pmos_rvt L=2e-08 W=1.08e-07 nfin=4 $X=14972 $Y=-10048 $D=0
M550 326 49 79 VDD! pmos_rvt L=2e-08 W=1.08e-07 nfin=4 $X=14972 $Y=-7880 $D=0
M551 75 37 VDD! VDD! pmos_rvt L=2e-08 W=1.08e-07 nfin=4 $X=14972 $Y=-5712 $D=0
M552 328 50 80 VDD! pmos_rvt L=2e-08 W=1.08e-07 nfin=4 $X=14972 $Y=-3544 $D=0
M553 330 51 81 VDD! pmos_rvt L=2e-08 W=1.08e-07 nfin=4 $X=14972 $Y=-1376 $D=0
M554 332 52 82 VDD! pmos_rvt L=2e-08 W=1.08e-07 nfin=4 $X=14972 $Y=792 $D=0
M555 335 B10 324 VDD! pmos_rvt L=2e-08 W=1.08e-07 nfin=4 $X=15188 $Y=-10048 $D=0
M556 337 B10 326 VDD! pmos_rvt L=2e-08 W=1.08e-07 nfin=4 $X=15188 $Y=-7880 $D=0
M557 340 B6 328 VDD! pmos_rvt L=2e-08 W=1.08e-07 nfin=4 $X=15188 $Y=-3544 $D=0
M558 342 B6 330 VDD! pmos_rvt L=2e-08 W=1.08e-07 nfin=4 $X=15188 $Y=-1376 $D=0
M559 344 B2 332 VDD! pmos_rvt L=2e-08 W=1.08e-07 nfin=4 $X=15188 $Y=792 $D=0
M560 VDD! A10 335 VDD! pmos_rvt L=2e-08 W=1.08e-07 nfin=4 $X=15404 $Y=-10048 $D=0
M561 VDD! A10 337 VDD! pmos_rvt L=2e-08 W=1.08e-07 nfin=4 $X=15404 $Y=-7880 $D=0
M562 VDD! A6 340 VDD! pmos_rvt L=2e-08 W=1.08e-07 nfin=4 $X=15404 $Y=-3544 $D=0
M563 VDD! A6 342 VDD! pmos_rvt L=2e-08 W=1.08e-07 nfin=4 $X=15404 $Y=-1376 $D=0
M564 VDD! A2 344 VDD! pmos_rvt L=2e-08 W=1.08e-07 nfin=4 $X=15404 $Y=792 $D=0
M565 VDD! 74 83 VDD! pmos_rvt L=2e-08 W=1.08e-07 nfin=4 $X=16052 $Y=-12216 $D=0
M566 VDD! 75 84 VDD! pmos_rvt L=2e-08 W=1.08e-07 nfin=4 $X=16052 $Y=-5712 $D=0
M567 346 76 VDD! VDD! pmos_rvt L=2e-08 W=1.08e-07 nfin=4 $X=16268 $Y=-12216 $D=0
M568 348 77 VDD! VDD! pmos_rvt L=2e-08 W=1.08e-07 nfin=4 $X=16268 $Y=-5712 $D=0
M569 87 74 346 VDD! pmos_rvt L=2e-08 W=1.08e-07 nfin=4 $X=16484 $Y=-12216 $D=0
M570 85 78 VDD! VDD! pmos_rvt L=2e-08 W=1.08e-07 nfin=4 $X=16484 $Y=-10048 $D=0
M571 76 79 VDD! VDD! pmos_rvt L=2e-08 W=1.08e-07 nfin=4 $X=16484 $Y=-7880 $D=0
M572 89 75 348 VDD! pmos_rvt L=2e-08 W=1.08e-07 nfin=4 $X=16484 $Y=-5712 $D=0
M573 86 80 VDD! VDD! pmos_rvt L=2e-08 W=1.08e-07 nfin=4 $X=16484 $Y=-3544 $D=0
M574 77 81 VDD! VDD! pmos_rvt L=2e-08 W=1.08e-07 nfin=4 $X=16484 $Y=-1376 $D=0
M575 S2 82 VDD! VDD! pmos_rvt L=2e-08 W=1.08e-07 nfin=4 $X=16484 $Y=792 $D=0
M576 356 83 87 VDD! pmos_rvt L=2e-08 W=1.08e-07 nfin=4 $X=17132 $Y=-12216 $D=0
M577 357 84 89 VDD! pmos_rvt L=2e-08 W=1.08e-07 nfin=4 $X=17132 $Y=-5712 $D=0
M578 VDD! 85 356 VDD! pmos_rvt L=2e-08 W=1.08e-07 nfin=4 $X=17348 $Y=-12216 $D=0
M579 VDD! 86 357 VDD! pmos_rvt L=2e-08 W=1.08e-07 nfin=4 $X=17348 $Y=-5712 $D=0
M580 S10 87 VDD! VDD! pmos_rvt L=2e-08 W=1.08e-07 nfin=4 $X=17564 $Y=-12216 $D=0
M581 99 B11 VDD! VDD! pmos_rvt L=2e-08 W=1.08e-07 nfin=4 $X=17564 $Y=-10048 $D=0
M582 100 B11 VDD! VDD! pmos_rvt L=2e-08 W=1.08e-07 nfin=4 $X=17564 $Y=-7880 $D=0
M583 S6 89 VDD! VDD! pmos_rvt L=2e-08 W=1.08e-07 nfin=4 $X=17564 $Y=-5712 $D=0
M584 101 B7 VDD! VDD! pmos_rvt L=2e-08 W=1.08e-07 nfin=4 $X=17564 $Y=-3544 $D=0
M585 102 B7 VDD! VDD! pmos_rvt L=2e-08 W=1.08e-07 nfin=4 $X=17564 $Y=-1376 $D=0
M586 103 B3 VDD! VDD! pmos_rvt L=2e-08 W=1.08e-07 nfin=4 $X=17564 $Y=792 $D=0
M587 VDD! 74 97 VDD! pmos_rvt L=2e-08 W=1.08e-07 nfin=4 $X=18644 $Y=-12216 $D=0
M588 105 A11 VDD! VDD! pmos_rvt L=2e-08 W=1.08e-07 nfin=4 $X=18644 $Y=-10048 $D=0
M589 106 A11 VDD! VDD! pmos_rvt L=2e-08 W=1.08e-07 nfin=4 $X=18644 $Y=-7880 $D=0
M590 VDD! 75 98 VDD! pmos_rvt L=2e-08 W=1.08e-07 nfin=4 $X=18644 $Y=-5712 $D=0
M591 108 A7 VDD! VDD! pmos_rvt L=2e-08 W=1.08e-07 nfin=4 $X=18644 $Y=-3544 $D=0
M592 109 A7 VDD! VDD! pmos_rvt L=2e-08 W=1.08e-07 nfin=4 $X=18644 $Y=-1376 $D=0
M593 110 A3 VDD! VDD! pmos_rvt L=2e-08 W=1.08e-07 nfin=4 $X=18644 $Y=792 $D=0
M594 364 95 VDD! VDD! pmos_rvt L=2e-08 W=1.08e-07 nfin=4 $X=18860 $Y=-12216 $D=0
M595 368 96 VDD! VDD! pmos_rvt L=2e-08 W=1.08e-07 nfin=4 $X=18860 $Y=-5712 $D=0
M596 111 74 364 VDD! pmos_rvt L=2e-08 W=1.08e-07 nfin=4 $X=19076 $Y=-12216 $D=0
M597 112 75 368 VDD! pmos_rvt L=2e-08 W=1.08e-07 nfin=4 $X=19076 $Y=-5712 $D=0
M598 374 97 111 VDD! pmos_rvt L=2e-08 W=1.08e-07 nfin=4 $X=19724 $Y=-12216 $D=0
M599 376 99 VDD! VDD! pmos_rvt L=2e-08 W=1.08e-07 nfin=4 $X=19724 $Y=-10048 $D=0
M600 378 100 VDD! VDD! pmos_rvt L=2e-08 W=1.08e-07 nfin=4 $X=19724 $Y=-7880 $D=0
M601 379 98 112 VDD! pmos_rvt L=2e-08 W=1.08e-07 nfin=4 $X=19724 $Y=-5712 $D=0
M602 381 101 VDD! VDD! pmos_rvt L=2e-08 W=1.08e-07 nfin=4 $X=19724 $Y=-3544 $D=0
M603 383 102 VDD! VDD! pmos_rvt L=2e-08 W=1.08e-07 nfin=4 $X=19724 $Y=-1376 $D=0
M604 385 103 VDD! VDD! pmos_rvt L=2e-08 W=1.08e-07 nfin=4 $X=19724 $Y=792 $D=0
M605 VDD! 104 374 VDD! pmos_rvt L=2e-08 W=1.08e-07 nfin=4 $X=19940 $Y=-12216 $D=0
M606 104 105 376 VDD! pmos_rvt L=2e-08 W=1.08e-07 nfin=4 $X=19940 $Y=-10048 $D=0
M607 95 106 378 VDD! pmos_rvt L=2e-08 W=1.08e-07 nfin=4 $X=19940 $Y=-7880 $D=0
M608 VDD! 107 379 VDD! pmos_rvt L=2e-08 W=1.08e-07 nfin=4 $X=19940 $Y=-5712 $D=0
M609 107 108 381 VDD! pmos_rvt L=2e-08 W=1.08e-07 nfin=4 $X=19940 $Y=-3544 $D=0
M610 96 109 383 VDD! pmos_rvt L=2e-08 W=1.08e-07 nfin=4 $X=19940 $Y=-1376 $D=0
M611 68 110 385 VDD! pmos_rvt L=2e-08 W=1.08e-07 nfin=4 $X=19940 $Y=792 $D=0
M612 121 111 VDD! VDD! pmos_rvt L=2e-08 W=1.08e-07 nfin=4 $X=20156 $Y=-12216 $D=0
M613 194 69 104 VDD! pmos_rvt L=2e-08 W=1.08e-07 nfin=4 $X=20156 $Y=-10048 $D=0
M614 196 70 95 VDD! pmos_rvt L=2e-08 W=1.08e-07 nfin=4 $X=20156 $Y=-7880 $D=0
M615 67 112 VDD! VDD! pmos_rvt L=2e-08 W=1.08e-07 nfin=4 $X=20156 $Y=-5712 $D=0
M616 198 71 107 VDD! pmos_rvt L=2e-08 W=1.08e-07 nfin=4 $X=20156 $Y=-3544 $D=0
M617 200 72 96 VDD! pmos_rvt L=2e-08 W=1.08e-07 nfin=4 $X=20156 $Y=-1376 $D=0
M618 202 73 68 VDD! pmos_rvt L=2e-08 W=1.08e-07 nfin=4 $X=20156 $Y=792 $D=0
M619 VDD! 105 194 VDD! pmos_rvt L=2e-08 W=1.08e-07 nfin=4 $X=20372 $Y=-10048 $D=0
M620 VDD! 106 196 VDD! pmos_rvt L=2e-08 W=1.08e-07 nfin=4 $X=20372 $Y=-7880 $D=0
M621 VDD! 108 198 VDD! pmos_rvt L=2e-08 W=1.08e-07 nfin=4 $X=20372 $Y=-3544 $D=0
M622 VDD! 109 200 VDD! pmos_rvt L=2e-08 W=1.08e-07 nfin=4 $X=20372 $Y=-1376 $D=0
M623 VDD! 110 202 VDD! pmos_rvt L=2e-08 W=1.08e-07 nfin=4 $X=20372 $Y=792 $D=0
M624 194 99 VDD! VDD! pmos_rvt L=2e-08 W=1.08e-07 nfin=4 $X=20588 $Y=-10048 $D=0
M625 196 100 VDD! VDD! pmos_rvt L=2e-08 W=1.08e-07 nfin=4 $X=20588 $Y=-7880 $D=0
M626 198 101 VDD! VDD! pmos_rvt L=2e-08 W=1.08e-07 nfin=4 $X=20588 $Y=-3544 $D=0
M627 200 102 VDD! VDD! pmos_rvt L=2e-08 W=1.08e-07 nfin=4 $X=20588 $Y=-1376 $D=0
M628 202 103 VDD! VDD! pmos_rvt L=2e-08 W=1.08e-07 nfin=4 $X=20588 $Y=792 $D=0
M629 VDD! 74 115 VDD! pmos_rvt L=2e-08 W=1.08e-07 nfin=4 $X=21236 $Y=-12216 $D=0
M630 VDD! 75 116 VDD! pmos_rvt L=2e-08 W=1.08e-07 nfin=4 $X=21236 $Y=-5712 $D=0
M631 387 113 VDD! VDD! pmos_rvt L=2e-08 W=1.08e-07 nfin=4 $X=21452 $Y=-12216 $D=0
M632 389 114 VDD! VDD! pmos_rvt L=2e-08 W=1.08e-07 nfin=4 $X=21452 $Y=-5712 $D=0
M633 119 74 387 VDD! pmos_rvt L=2e-08 W=1.08e-07 nfin=4 $X=21668 $Y=-12216 $D=0
M634 205 105 VDD! VDD! pmos_rvt L=2e-08 W=1.08e-07 nfin=4 $X=21668 $Y=-10048 $D=0
M635 207 106 VDD! VDD! pmos_rvt L=2e-08 W=1.08e-07 nfin=4 $X=21668 $Y=-7880 $D=0
M636 120 75 389 VDD! pmos_rvt L=2e-08 W=1.08e-07 nfin=4 $X=21668 $Y=-5712 $D=0
M637 209 108 VDD! VDD! pmos_rvt L=2e-08 W=1.08e-07 nfin=4 $X=21668 $Y=-3544 $D=0
M638 211 109 VDD! VDD! pmos_rvt L=2e-08 W=1.08e-07 nfin=4 $X=21668 $Y=-1376 $D=0
M639 213 110 VDD! VDD! pmos_rvt L=2e-08 W=1.08e-07 nfin=4 $X=21668 $Y=792 $D=0
M640 VDD! 99 205 VDD! pmos_rvt L=2e-08 W=1.08e-07 nfin=4 $X=21884 $Y=-10048 $D=0
M641 VDD! 100 207 VDD! pmos_rvt L=2e-08 W=1.08e-07 nfin=4 $X=21884 $Y=-7880 $D=0
M642 VDD! 101 209 VDD! pmos_rvt L=2e-08 W=1.08e-07 nfin=4 $X=21884 $Y=-3544 $D=0
M643 VDD! 102 211 VDD! pmos_rvt L=2e-08 W=1.08e-07 nfin=4 $X=21884 $Y=-1376 $D=0
M644 VDD! 103 213 VDD! pmos_rvt L=2e-08 W=1.08e-07 nfin=4 $X=21884 $Y=792 $D=0
M645 205 69 VDD! VDD! pmos_rvt L=2e-08 W=1.08e-07 nfin=4 $X=22100 $Y=-10048 $D=0
M646 207 70 VDD! VDD! pmos_rvt L=2e-08 W=1.08e-07 nfin=4 $X=22100 $Y=-7880 $D=0
M647 209 71 VDD! VDD! pmos_rvt L=2e-08 W=1.08e-07 nfin=4 $X=22100 $Y=-3544 $D=0
M648 211 72 VDD! VDD! pmos_rvt L=2e-08 W=1.08e-07 nfin=4 $X=22100 $Y=-1376 $D=0
M649 213 73 VDD! VDD! pmos_rvt L=2e-08 W=1.08e-07 nfin=4 $X=22100 $Y=792 $D=0
M650 392 115 119 VDD! pmos_rvt L=2e-08 W=1.08e-07 nfin=4 $X=22316 $Y=-12216 $D=0
M651 117 104 205 VDD! pmos_rvt L=2e-08 W=1.08e-07 nfin=4 $X=22316 $Y=-10048 $D=0
M652 113 95 207 VDD! pmos_rvt L=2e-08 W=1.08e-07 nfin=4 $X=22316 $Y=-7880 $D=0
M653 393 116 120 VDD! pmos_rvt L=2e-08 W=1.08e-07 nfin=4 $X=22316 $Y=-5712 $D=0
M654 118 107 209 VDD! pmos_rvt L=2e-08 W=1.08e-07 nfin=4 $X=22316 $Y=-3544 $D=0
M655 114 96 211 VDD! pmos_rvt L=2e-08 W=1.08e-07 nfin=4 $X=22316 $Y=-1376 $D=0
M656 S3 68 213 VDD! pmos_rvt L=2e-08 W=1.08e-07 nfin=4 $X=22316 $Y=792 $D=0
M657 VDD! 117 392 VDD! pmos_rvt L=2e-08 W=1.08e-07 nfin=4 $X=22532 $Y=-12216 $D=0
M658 395 69 117 VDD! pmos_rvt L=2e-08 W=1.08e-07 nfin=4 $X=22532 $Y=-10048 $D=0
M659 397 70 113 VDD! pmos_rvt L=2e-08 W=1.08e-07 nfin=4 $X=22532 $Y=-7880 $D=0
M660 VDD! 118 393 VDD! pmos_rvt L=2e-08 W=1.08e-07 nfin=4 $X=22532 $Y=-5712 $D=0
M661 399 71 118 VDD! pmos_rvt L=2e-08 W=1.08e-07 nfin=4 $X=22532 $Y=-3544 $D=0
M662 401 72 114 VDD! pmos_rvt L=2e-08 W=1.08e-07 nfin=4 $X=22532 $Y=-1376 $D=0
M663 403 73 S3 VDD! pmos_rvt L=2e-08 W=1.08e-07 nfin=4 $X=22532 $Y=792 $D=0
M664 S11 119 VDD! VDD! pmos_rvt L=2e-08 W=1.08e-07 nfin=4 $X=22748 $Y=-12216 $D=0
M665 405 99 395 VDD! pmos_rvt L=2e-08 W=1.08e-07 nfin=4 $X=22748 $Y=-10048 $D=0
M666 407 100 397 VDD! pmos_rvt L=2e-08 W=1.08e-07 nfin=4 $X=22748 $Y=-7880 $D=0
M667 S7 120 VDD! VDD! pmos_rvt L=2e-08 W=1.08e-07 nfin=4 $X=22748 $Y=-5712 $D=0
M668 409 101 399 VDD! pmos_rvt L=2e-08 W=1.08e-07 nfin=4 $X=22748 $Y=-3544 $D=0
M669 411 102 401 VDD! pmos_rvt L=2e-08 W=1.08e-07 nfin=4 $X=22748 $Y=-1376 $D=0
M670 413 103 403 VDD! pmos_rvt L=2e-08 W=1.08e-07 nfin=4 $X=22748 $Y=792 $D=0
M671 VDD! 105 405 VDD! pmos_rvt L=2e-08 W=1.08e-07 nfin=4 $X=22964 $Y=-10048 $D=0
M672 VDD! 106 407 VDD! pmos_rvt L=2e-08 W=1.08e-07 nfin=4 $X=22964 $Y=-7880 $D=0
M673 VDD! 108 409 VDD! pmos_rvt L=2e-08 W=1.08e-07 nfin=4 $X=22964 $Y=-3544 $D=0
M674 VDD! 109 411 VDD! pmos_rvt L=2e-08 W=1.08e-07 nfin=4 $X=22964 $Y=-1376 $D=0
M675 VDD! 110 413 VDD! pmos_rvt L=2e-08 W=1.08e-07 nfin=4 $X=22964 $Y=792 $D=0
M676 122 121 VDD! VDD! pmos_rvt L=2e-08 W=1.08e-07 nfin=4 $X=23828 $Y=-12216 $D=0
M677 415 122 VDD! VDD! pmos_rvt L=2e-08 W=1.08e-07 nfin=4 $X=23828 $Y=-5712 $D=0
M678 VDD! 121 122 VDD! pmos_rvt L=2e-08 W=1.08e-07 nfin=4 $X=24044 $Y=-12216 $D=0
M679 S12 122 415 VDD! pmos_rvt L=2e-08 W=1.08e-07 nfin=4 $X=24044 $Y=-5712 $D=0
.ENDS
***************************************
