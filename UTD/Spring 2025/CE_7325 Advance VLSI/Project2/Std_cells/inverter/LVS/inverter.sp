* SPICE NETLIST
***************************************

.SUBCKT inverter
** N=1 EP=0 IP=0 FDC=0
.ENDS
***************************************
