* SPICE NETLIST
***************************************

.SUBCKT Carry_sel GND! VDD! B0 A0 B1 A1 B2 A2 C_IN B3 A3 OUT0 OUT1 OUT2 C_OUT OUT3
** N=529 EP=16 IP=0 FDC=282
M0 90 B0 GND! GND! nmos_rvt L=2e-08 W=1.08e-07 nfin=4 $X=284 $Y=-2024 $D=1
M1 92 B0 GND! GND! nmos_rvt L=2e-08 W=1.08e-07 nfin=4 $X=284 $Y=144 $D=1
M2 5 A0 90 GND! nmos_rvt L=2e-08 W=1.08e-07 nfin=4 $X=500 $Y=-2024 $D=1
M3 6 A0 92 GND! nmos_rvt L=2e-08 W=1.08e-07 nfin=4 $X=500 $Y=144 $D=1
M4 53 GND! 5 GND! nmos_rvt L=2e-08 W=1.08e-07 nfin=4 $X=716 $Y=-2024 $D=1
M5 55 VDD! 6 GND! nmos_rvt L=2e-08 W=1.08e-07 nfin=4 $X=716 $Y=144 $D=1
M6 GND! A0 53 GND! nmos_rvt L=2e-08 W=1.08e-07 nfin=4 $X=932 $Y=-2024 $D=1
M7 GND! A0 55 GND! nmos_rvt L=2e-08 W=1.08e-07 nfin=4 $X=932 $Y=144 $D=1
M8 53 B0 GND! GND! nmos_rvt L=2e-08 W=1.08e-07 nfin=4 $X=1148 $Y=-2024 $D=1
M9 55 B0 GND! GND! nmos_rvt L=2e-08 W=1.08e-07 nfin=4 $X=1148 $Y=144 $D=1
M10 57 A0 GND! GND! nmos_rvt L=2e-08 W=1.08e-07 nfin=4 $X=2228 $Y=-2024 $D=1
M11 59 A0 GND! GND! nmos_rvt L=2e-08 W=1.08e-07 nfin=4 $X=2228 $Y=144 $D=1
M12 GND! B0 57 GND! nmos_rvt L=2e-08 W=1.08e-07 nfin=4 $X=2444 $Y=-2024 $D=1
M13 GND! B0 59 GND! nmos_rvt L=2e-08 W=1.08e-07 nfin=4 $X=2444 $Y=144 $D=1
M14 57 GND! GND! GND! nmos_rvt L=2e-08 W=1.08e-07 nfin=4 $X=2660 $Y=-2024 $D=1
M15 59 VDD! GND! GND! nmos_rvt L=2e-08 W=1.08e-07 nfin=4 $X=2660 $Y=144 $D=1
M16 9 5 57 GND! nmos_rvt L=2e-08 W=1.08e-07 nfin=4 $X=2876 $Y=-2024 $D=1
M17 10 6 59 GND! nmos_rvt L=2e-08 W=1.08e-07 nfin=4 $X=2876 $Y=144 $D=1
M18 94 GND! 9 GND! nmos_rvt L=2e-08 W=1.08e-07 nfin=4 $X=3092 $Y=-2024 $D=1
M19 96 VDD! 10 GND! nmos_rvt L=2e-08 W=1.08e-07 nfin=4 $X=3092 $Y=144 $D=1
M20 98 B0 94 GND! nmos_rvt L=2e-08 W=1.08e-07 nfin=4 $X=3308 $Y=-2024 $D=1
M21 100 B0 96 GND! nmos_rvt L=2e-08 W=1.08e-07 nfin=4 $X=3308 $Y=144 $D=1
M22 GND! A0 98 GND! nmos_rvt L=2e-08 W=1.08e-07 nfin=4 $X=3524 $Y=-2024 $D=1
M23 GND! A0 100 GND! nmos_rvt L=2e-08 W=1.08e-07 nfin=4 $X=3524 $Y=144 $D=1
M24 GND! 7 11 GND! nmos_rvt L=2e-08 W=1.08e-07 nfin=4 $X=4172 $Y=-4192 $D=1
M25 102 8 GND! GND! nmos_rvt L=2e-08 W=1.08e-07 nfin=4 $X=4388 $Y=-4192 $D=1
M26 12 9 GND! GND! nmos_rvt L=2e-08 W=1.08e-07 nfin=4 $X=4604 $Y=-2024 $D=1
M27 8 10 GND! GND! nmos_rvt L=2e-08 W=1.08e-07 nfin=4 $X=4604 $Y=144 $D=1
M28 13 11 102 GND! nmos_rvt L=2e-08 W=1.08e-07 nfin=4 $X=4820 $Y=-4192 $D=1
M29 106 7 13 GND! nmos_rvt L=2e-08 W=1.08e-07 nfin=4 $X=5036 $Y=-4192 $D=1
M30 GND! 12 106 GND! nmos_rvt L=2e-08 W=1.08e-07 nfin=4 $X=5468 $Y=-4192 $D=1
M31 OUT0 13 GND! GND! nmos_rvt L=2e-08 W=1.08e-07 nfin=4 $X=5684 $Y=-4192 $D=1
M32 17 B1 GND! GND! nmos_rvt L=2e-08 W=1.08e-07 nfin=4 $X=5684 $Y=-2024 $D=1
M33 18 B1 GND! GND! nmos_rvt L=2e-08 W=1.08e-07 nfin=4 $X=5684 $Y=144 $D=1
M34 19 A1 GND! GND! nmos_rvt L=2e-08 W=1.08e-07 nfin=4 $X=6764 $Y=-2024 $D=1
M35 20 A1 GND! GND! nmos_rvt L=2e-08 W=1.08e-07 nfin=4 $X=6764 $Y=144 $D=1
M36 7 16 GND! GND! nmos_rvt L=2e-08 W=1.08e-07 nfin=4 $X=7196 $Y=-4192 $D=1
M37 113 17 GND! GND! nmos_rvt L=2e-08 W=1.08e-07 nfin=4 $X=7844 $Y=-2024 $D=1
M38 115 18 GND! GND! nmos_rvt L=2e-08 W=1.08e-07 nfin=4 $X=7844 $Y=144 $D=1
M39 21 19 113 GND! nmos_rvt L=2e-08 W=1.08e-07 nfin=4 $X=8060 $Y=-2024 $D=1
M40 22 20 115 GND! nmos_rvt L=2e-08 W=1.08e-07 nfin=4 $X=8060 $Y=144 $D=1
M41 62 5 21 GND! nmos_rvt L=2e-08 W=1.08e-07 nfin=4 $X=8276 $Y=-2024 $D=1
M42 64 6 22 GND! nmos_rvt L=2e-08 W=1.08e-07 nfin=4 $X=8276 $Y=144 $D=1
M43 GND! 19 62 GND! nmos_rvt L=2e-08 W=1.08e-07 nfin=4 $X=8492 $Y=-2024 $D=1
M44 GND! 20 64 GND! nmos_rvt L=2e-08 W=1.08e-07 nfin=4 $X=8492 $Y=144 $D=1
M45 62 17 GND! GND! nmos_rvt L=2e-08 W=1.08e-07 nfin=4 $X=8708 $Y=-2024 $D=1
M46 64 18 GND! GND! nmos_rvt L=2e-08 W=1.08e-07 nfin=4 $X=8708 $Y=144 $D=1
M47 66 19 GND! GND! nmos_rvt L=2e-08 W=1.08e-07 nfin=4 $X=9788 $Y=-2024 $D=1
M48 68 20 GND! GND! nmos_rvt L=2e-08 W=1.08e-07 nfin=4 $X=9788 $Y=144 $D=1
M49 GND! 17 66 GND! nmos_rvt L=2e-08 W=1.08e-07 nfin=4 $X=10004 $Y=-2024 $D=1
M50 GND! 18 68 GND! nmos_rvt L=2e-08 W=1.08e-07 nfin=4 $X=10004 $Y=144 $D=1
M51 66 5 GND! GND! nmos_rvt L=2e-08 W=1.08e-07 nfin=4 $X=10220 $Y=-2024 $D=1
M52 68 6 GND! GND! nmos_rvt L=2e-08 W=1.08e-07 nfin=4 $X=10220 $Y=144 $D=1
M53 GND! 7 24 GND! nmos_rvt L=2e-08 W=1.08e-07 nfin=4 $X=10436 $Y=-4192 $D=1
M54 25 21 66 GND! nmos_rvt L=2e-08 W=1.08e-07 nfin=4 $X=10436 $Y=-2024 $D=1
M55 23 22 68 GND! nmos_rvt L=2e-08 W=1.08e-07 nfin=4 $X=10436 $Y=144 $D=1
M56 117 23 GND! GND! nmos_rvt L=2e-08 W=1.08e-07 nfin=4 $X=10652 $Y=-4192 $D=1
M57 119 5 25 GND! nmos_rvt L=2e-08 W=1.08e-07 nfin=4 $X=10652 $Y=-2024 $D=1
M58 121 6 23 GND! nmos_rvt L=2e-08 W=1.08e-07 nfin=4 $X=10652 $Y=144 $D=1
M59 123 17 119 GND! nmos_rvt L=2e-08 W=1.08e-07 nfin=4 $X=10868 $Y=-2024 $D=1
M60 125 18 121 GND! nmos_rvt L=2e-08 W=1.08e-07 nfin=4 $X=10868 $Y=144 $D=1
M61 26 24 117 GND! nmos_rvt L=2e-08 W=1.08e-07 nfin=4 $X=11084 $Y=-4192 $D=1
M62 GND! 19 123 GND! nmos_rvt L=2e-08 W=1.08e-07 nfin=4 $X=11084 $Y=-2024 $D=1
M63 GND! 20 125 GND! nmos_rvt L=2e-08 W=1.08e-07 nfin=4 $X=11084 $Y=144 $D=1
M64 127 7 26 GND! nmos_rvt L=2e-08 W=1.08e-07 nfin=4 $X=11300 $Y=-4192 $D=1
M65 GND! 25 127 GND! nmos_rvt L=2e-08 W=1.08e-07 nfin=4 $X=11732 $Y=-4192 $D=1
M66 OUT1 26 GND! GND! nmos_rvt L=2e-08 W=1.08e-07 nfin=4 $X=11948 $Y=-4192 $D=1
M67 129 B2 GND! GND! nmos_rvt L=2e-08 W=1.08e-07 nfin=4 $X=12164 $Y=-2024 $D=1
M68 131 B2 GND! GND! nmos_rvt L=2e-08 W=1.08e-07 nfin=4 $X=12164 $Y=144 $D=1
M69 30 A2 129 GND! nmos_rvt L=2e-08 W=1.08e-07 nfin=4 $X=12380 $Y=-2024 $D=1
M70 31 A2 131 GND! nmos_rvt L=2e-08 W=1.08e-07 nfin=4 $X=12380 $Y=144 $D=1
M71 71 21 30 GND! nmos_rvt L=2e-08 W=1.08e-07 nfin=4 $X=12596 $Y=-2024 $D=1
M72 73 22 31 GND! nmos_rvt L=2e-08 W=1.08e-07 nfin=4 $X=12596 $Y=144 $D=1
M73 GND! A2 71 GND! nmos_rvt L=2e-08 W=1.08e-07 nfin=4 $X=12812 $Y=-2024 $D=1
M74 GND! A2 73 GND! nmos_rvt L=2e-08 W=1.08e-07 nfin=4 $X=12812 $Y=144 $D=1
M75 71 B2 GND! GND! nmos_rvt L=2e-08 W=1.08e-07 nfin=4 $X=13028 $Y=-2024 $D=1
M76 73 B2 GND! GND! nmos_rvt L=2e-08 W=1.08e-07 nfin=4 $X=13028 $Y=144 $D=1
M77 16 C_IN GND! GND! nmos_rvt L=2e-08 W=1.08e-07 nfin=4 $X=13892 $Y=-4192 $D=1
M78 75 A2 GND! GND! nmos_rvt L=2e-08 W=1.08e-07 nfin=4 $X=14108 $Y=-2024 $D=1
M79 77 A2 GND! GND! nmos_rvt L=2e-08 W=1.08e-07 nfin=4 $X=14108 $Y=144 $D=1
M80 GND! B2 75 GND! nmos_rvt L=2e-08 W=1.08e-07 nfin=4 $X=14324 $Y=-2024 $D=1
M81 GND! B2 77 GND! nmos_rvt L=2e-08 W=1.08e-07 nfin=4 $X=14324 $Y=144 $D=1
M82 75 21 GND! GND! nmos_rvt L=2e-08 W=1.08e-07 nfin=4 $X=14540 $Y=-2024 $D=1
M83 77 22 GND! GND! nmos_rvt L=2e-08 W=1.08e-07 nfin=4 $X=14540 $Y=144 $D=1
M84 34 30 75 GND! nmos_rvt L=2e-08 W=1.08e-07 nfin=4 $X=14756 $Y=-2024 $D=1
M85 35 31 77 GND! nmos_rvt L=2e-08 W=1.08e-07 nfin=4 $X=14756 $Y=144 $D=1
M86 32 16 GND! GND! nmos_rvt L=2e-08 W=1.08e-07 nfin=4 $X=14972 $Y=-4192 $D=1
M87 134 21 34 GND! nmos_rvt L=2e-08 W=1.08e-07 nfin=4 $X=14972 $Y=-2024 $D=1
M88 136 22 35 GND! nmos_rvt L=2e-08 W=1.08e-07 nfin=4 $X=14972 $Y=144 $D=1
M89 139 B2 134 GND! nmos_rvt L=2e-08 W=1.08e-07 nfin=4 $X=15188 $Y=-2024 $D=1
M90 141 B2 136 GND! nmos_rvt L=2e-08 W=1.08e-07 nfin=4 $X=15188 $Y=144 $D=1
M91 GND! A2 139 GND! nmos_rvt L=2e-08 W=1.08e-07 nfin=4 $X=15404 $Y=-2024 $D=1
M92 GND! A2 141 GND! nmos_rvt L=2e-08 W=1.08e-07 nfin=4 $X=15404 $Y=144 $D=1
M93 GND! 32 36 GND! nmos_rvt L=2e-08 W=1.08e-07 nfin=4 $X=16052 $Y=-4192 $D=1
M94 143 33 GND! GND! nmos_rvt L=2e-08 W=1.08e-07 nfin=4 $X=16268 $Y=-4192 $D=1
M95 37 34 GND! GND! nmos_rvt L=2e-08 W=1.08e-07 nfin=4 $X=16484 $Y=-2024 $D=1
M96 33 35 GND! GND! nmos_rvt L=2e-08 W=1.08e-07 nfin=4 $X=16484 $Y=144 $D=1
M97 38 36 143 GND! nmos_rvt L=2e-08 W=1.08e-07 nfin=4 $X=16700 $Y=-4192 $D=1
M98 147 32 38 GND! nmos_rvt L=2e-08 W=1.08e-07 nfin=4 $X=16916 $Y=-4192 $D=1
M99 GND! 37 147 GND! nmos_rvt L=2e-08 W=1.08e-07 nfin=4 $X=17348 $Y=-4192 $D=1
M100 OUT2 38 GND! GND! nmos_rvt L=2e-08 W=1.08e-07 nfin=4 $X=17564 $Y=-4192 $D=1
M101 43 B3 GND! GND! nmos_rvt L=2e-08 W=1.08e-07 nfin=4 $X=17564 $Y=-2024 $D=1
M102 44 B3 GND! GND! nmos_rvt L=2e-08 W=1.08e-07 nfin=4 $X=17564 $Y=144 $D=1
M103 GND! 32 42 GND! nmos_rvt L=2e-08 W=1.08e-07 nfin=4 $X=18644 $Y=-4192 $D=1
M104 46 A3 GND! GND! nmos_rvt L=2e-08 W=1.08e-07 nfin=4 $X=18644 $Y=-2024 $D=1
M105 47 A3 GND! GND! nmos_rvt L=2e-08 W=1.08e-07 nfin=4 $X=18644 $Y=144 $D=1
M106 151 41 GND! GND! nmos_rvt L=2e-08 W=1.08e-07 nfin=4 $X=18860 $Y=-4192 $D=1
M107 48 42 151 GND! nmos_rvt L=2e-08 W=1.08e-07 nfin=4 $X=19292 $Y=-4192 $D=1
M108 155 32 48 GND! nmos_rvt L=2e-08 W=1.08e-07 nfin=4 $X=19508 $Y=-4192 $D=1
M109 157 43 GND! GND! nmos_rvt L=2e-08 W=1.08e-07 nfin=4 $X=19724 $Y=-2024 $D=1
M110 159 44 GND! GND! nmos_rvt L=2e-08 W=1.08e-07 nfin=4 $X=19724 $Y=144 $D=1
M111 GND! 45 155 GND! nmos_rvt L=2e-08 W=1.08e-07 nfin=4 $X=19940 $Y=-4192 $D=1
M112 45 46 157 GND! nmos_rvt L=2e-08 W=1.08e-07 nfin=4 $X=19940 $Y=-2024 $D=1
M113 41 47 159 GND! nmos_rvt L=2e-08 W=1.08e-07 nfin=4 $X=19940 $Y=144 $D=1
M114 C_OUT 48 GND! GND! nmos_rvt L=2e-08 W=1.08e-07 nfin=4 $X=20156 $Y=-4192 $D=1
M115 81 30 45 GND! nmos_rvt L=2e-08 W=1.08e-07 nfin=4 $X=20156 $Y=-2024 $D=1
M116 83 31 41 GND! nmos_rvt L=2e-08 W=1.08e-07 nfin=4 $X=20156 $Y=144 $D=1
M117 GND! 46 81 GND! nmos_rvt L=2e-08 W=1.08e-07 nfin=4 $X=20372 $Y=-2024 $D=1
M118 GND! 47 83 GND! nmos_rvt L=2e-08 W=1.08e-07 nfin=4 $X=20372 $Y=144 $D=1
M119 81 43 GND! GND! nmos_rvt L=2e-08 W=1.08e-07 nfin=4 $X=20588 $Y=-2024 $D=1
M120 83 44 GND! GND! nmos_rvt L=2e-08 W=1.08e-07 nfin=4 $X=20588 $Y=144 $D=1
M121 GND! 32 50 GND! nmos_rvt L=2e-08 W=1.08e-07 nfin=4 $X=21236 $Y=-4192 $D=1
M122 161 49 GND! GND! nmos_rvt L=2e-08 W=1.08e-07 nfin=4 $X=21452 $Y=-4192 $D=1
M123 85 46 GND! GND! nmos_rvt L=2e-08 W=1.08e-07 nfin=4 $X=21668 $Y=-2024 $D=1
M124 87 47 GND! GND! nmos_rvt L=2e-08 W=1.08e-07 nfin=4 $X=21668 $Y=144 $D=1
M125 52 50 161 GND! nmos_rvt L=2e-08 W=1.08e-07 nfin=4 $X=21884 $Y=-4192 $D=1
M126 GND! 43 85 GND! nmos_rvt L=2e-08 W=1.08e-07 nfin=4 $X=21884 $Y=-2024 $D=1
M127 GND! 44 87 GND! nmos_rvt L=2e-08 W=1.08e-07 nfin=4 $X=21884 $Y=144 $D=1
M128 163 32 52 GND! nmos_rvt L=2e-08 W=1.08e-07 nfin=4 $X=22100 $Y=-4192 $D=1
M129 85 30 GND! GND! nmos_rvt L=2e-08 W=1.08e-07 nfin=4 $X=22100 $Y=-2024 $D=1
M130 87 31 GND! GND! nmos_rvt L=2e-08 W=1.08e-07 nfin=4 $X=22100 $Y=144 $D=1
M131 51 45 85 GND! nmos_rvt L=2e-08 W=1.08e-07 nfin=4 $X=22316 $Y=-2024 $D=1
M132 49 41 87 GND! nmos_rvt L=2e-08 W=1.08e-07 nfin=4 $X=22316 $Y=144 $D=1
M133 GND! 51 163 GND! nmos_rvt L=2e-08 W=1.08e-07 nfin=4 $X=22532 $Y=-4192 $D=1
M134 165 30 51 GND! nmos_rvt L=2e-08 W=1.08e-07 nfin=4 $X=22532 $Y=-2024 $D=1
M135 167 31 49 GND! nmos_rvt L=2e-08 W=1.08e-07 nfin=4 $X=22532 $Y=144 $D=1
M136 OUT3 52 GND! GND! nmos_rvt L=2e-08 W=1.08e-07 nfin=4 $X=22748 $Y=-4192 $D=1
M137 169 43 165 GND! nmos_rvt L=2e-08 W=1.08e-07 nfin=4 $X=22748 $Y=-2024 $D=1
M138 171 44 167 GND! nmos_rvt L=2e-08 W=1.08e-07 nfin=4 $X=22748 $Y=144 $D=1
M139 GND! 46 169 GND! nmos_rvt L=2e-08 W=1.08e-07 nfin=4 $X=22964 $Y=-2024 $D=1
M140 GND! 47 171 GND! nmos_rvt L=2e-08 W=1.08e-07 nfin=4 $X=22964 $Y=144 $D=1
M141 91 B0 VDD! VDD! pmos_rvt L=2e-08 W=1.08e-07 nfin=4 $X=284 $Y=-1376 $D=0
M142 93 B0 VDD! VDD! pmos_rvt L=2e-08 W=1.08e-07 nfin=4 $X=284 $Y=792 $D=0
M143 5 A0 91 VDD! pmos_rvt L=2e-08 W=1.08e-07 nfin=4 $X=500 $Y=-1376 $D=0
M144 6 A0 93 VDD! pmos_rvt L=2e-08 W=1.08e-07 nfin=4 $X=500 $Y=792 $D=0
M145 54 GND! 5 VDD! pmos_rvt L=2e-08 W=1.08e-07 nfin=4 $X=716 $Y=-1376 $D=0
M146 56 VDD! 6 VDD! pmos_rvt L=2e-08 W=1.08e-07 nfin=4 $X=716 $Y=792 $D=0
M147 VDD! A0 54 VDD! pmos_rvt L=2e-08 W=1.08e-07 nfin=4 $X=932 $Y=-1376 $D=0
M148 VDD! A0 56 VDD! pmos_rvt L=2e-08 W=1.08e-07 nfin=4 $X=932 $Y=792 $D=0
M149 54 B0 VDD! VDD! pmos_rvt L=2e-08 W=1.08e-07 nfin=4 $X=1148 $Y=-1376 $D=0
M150 56 B0 VDD! VDD! pmos_rvt L=2e-08 W=1.08e-07 nfin=4 $X=1148 $Y=792 $D=0
M151 58 A0 VDD! VDD! pmos_rvt L=2e-08 W=1.08e-07 nfin=4 $X=2228 $Y=-1376 $D=0
M152 60 A0 VDD! VDD! pmos_rvt L=2e-08 W=1.08e-07 nfin=4 $X=2228 $Y=792 $D=0
M153 VDD! B0 58 VDD! pmos_rvt L=2e-08 W=1.08e-07 nfin=4 $X=2444 $Y=-1376 $D=0
M154 VDD! B0 60 VDD! pmos_rvt L=2e-08 W=1.08e-07 nfin=4 $X=2444 $Y=792 $D=0
M155 58 GND! VDD! VDD! pmos_rvt L=2e-08 W=1.08e-07 nfin=4 $X=2660 $Y=-1376 $D=0
M156 60 VDD! VDD! VDD! pmos_rvt L=2e-08 W=1.08e-07 nfin=4 $X=2660 $Y=792 $D=0
M157 9 5 58 VDD! pmos_rvt L=2e-08 W=1.08e-07 nfin=4 $X=2876 $Y=-1376 $D=0
M158 10 6 60 VDD! pmos_rvt L=2e-08 W=1.08e-07 nfin=4 $X=2876 $Y=792 $D=0
M159 95 GND! 9 VDD! pmos_rvt L=2e-08 W=1.08e-07 nfin=4 $X=3092 $Y=-1376 $D=0
M160 97 VDD! 10 VDD! pmos_rvt L=2e-08 W=1.08e-07 nfin=4 $X=3092 $Y=792 $D=0
M161 99 B0 95 VDD! pmos_rvt L=2e-08 W=1.08e-07 nfin=4 $X=3308 $Y=-1376 $D=0
M162 101 B0 97 VDD! pmos_rvt L=2e-08 W=1.08e-07 nfin=4 $X=3308 $Y=792 $D=0
M163 VDD! A0 99 VDD! pmos_rvt L=2e-08 W=1.08e-07 nfin=4 $X=3524 $Y=-1376 $D=0
M164 VDD! A0 101 VDD! pmos_rvt L=2e-08 W=1.08e-07 nfin=4 $X=3524 $Y=792 $D=0
M165 VDD! 7 11 VDD! pmos_rvt L=2e-08 W=1.08e-07 nfin=4 $X=4172 $Y=-3544 $D=0
M166 103 8 VDD! VDD! pmos_rvt L=2e-08 W=1.08e-07 nfin=4 $X=4388 $Y=-3544 $D=0
M167 13 7 103 VDD! pmos_rvt L=2e-08 W=1.08e-07 nfin=4 $X=4604 $Y=-3544 $D=0
M168 12 9 VDD! VDD! pmos_rvt L=2e-08 W=1.08e-07 nfin=4 $X=4604 $Y=-1376 $D=0
M169 8 10 VDD! VDD! pmos_rvt L=2e-08 W=1.08e-07 nfin=4 $X=4604 $Y=792 $D=0
M170 107 11 13 VDD! pmos_rvt L=2e-08 W=1.08e-07 nfin=4 $X=5252 $Y=-3544 $D=0
M171 VDD! 12 107 VDD! pmos_rvt L=2e-08 W=1.08e-07 nfin=4 $X=5468 $Y=-3544 $D=0
M172 OUT0 13 VDD! VDD! pmos_rvt L=2e-08 W=1.08e-07 nfin=4 $X=5684 $Y=-3544 $D=0
M173 17 B1 VDD! VDD! pmos_rvt L=2e-08 W=1.08e-07 nfin=4 $X=5684 $Y=-1376 $D=0
M174 18 B1 VDD! VDD! pmos_rvt L=2e-08 W=1.08e-07 nfin=4 $X=5684 $Y=792 $D=0
M175 19 A1 VDD! VDD! pmos_rvt L=2e-08 W=1.08e-07 nfin=4 $X=6764 $Y=-1376 $D=0
M176 20 A1 VDD! VDD! pmos_rvt L=2e-08 W=1.08e-07 nfin=4 $X=6764 $Y=792 $D=0
M177 7 16 VDD! VDD! pmos_rvt L=2e-08 W=1.08e-07 nfin=4 $X=7196 $Y=-3544 $D=0
M178 114 17 VDD! VDD! pmos_rvt L=2e-08 W=1.08e-07 nfin=4 $X=7844 $Y=-1376 $D=0
M179 116 18 VDD! VDD! pmos_rvt L=2e-08 W=1.08e-07 nfin=4 $X=7844 $Y=792 $D=0
M180 21 19 114 VDD! pmos_rvt L=2e-08 W=1.08e-07 nfin=4 $X=8060 $Y=-1376 $D=0
M181 22 20 116 VDD! pmos_rvt L=2e-08 W=1.08e-07 nfin=4 $X=8060 $Y=792 $D=0
M182 63 5 21 VDD! pmos_rvt L=2e-08 W=1.08e-07 nfin=4 $X=8276 $Y=-1376 $D=0
M183 65 6 22 VDD! pmos_rvt L=2e-08 W=1.08e-07 nfin=4 $X=8276 $Y=792 $D=0
M184 VDD! 19 63 VDD! pmos_rvt L=2e-08 W=1.08e-07 nfin=4 $X=8492 $Y=-1376 $D=0
M185 VDD! 20 65 VDD! pmos_rvt L=2e-08 W=1.08e-07 nfin=4 $X=8492 $Y=792 $D=0
M186 63 17 VDD! VDD! pmos_rvt L=2e-08 W=1.08e-07 nfin=4 $X=8708 $Y=-1376 $D=0
M187 65 18 VDD! VDD! pmos_rvt L=2e-08 W=1.08e-07 nfin=4 $X=8708 $Y=792 $D=0
M188 67 19 VDD! VDD! pmos_rvt L=2e-08 W=1.08e-07 nfin=4 $X=9788 $Y=-1376 $D=0
M189 69 20 VDD! VDD! pmos_rvt L=2e-08 W=1.08e-07 nfin=4 $X=9788 $Y=792 $D=0
M190 VDD! 17 67 VDD! pmos_rvt L=2e-08 W=1.08e-07 nfin=4 $X=10004 $Y=-1376 $D=0
M191 VDD! 18 69 VDD! pmos_rvt L=2e-08 W=1.08e-07 nfin=4 $X=10004 $Y=792 $D=0
M192 67 5 VDD! VDD! pmos_rvt L=2e-08 W=1.08e-07 nfin=4 $X=10220 $Y=-1376 $D=0
M193 69 6 VDD! VDD! pmos_rvt L=2e-08 W=1.08e-07 nfin=4 $X=10220 $Y=792 $D=0
M194 VDD! 7 24 VDD! pmos_rvt L=2e-08 W=1.08e-07 nfin=4 $X=10436 $Y=-3544 $D=0
M195 25 21 67 VDD! pmos_rvt L=2e-08 W=1.08e-07 nfin=4 $X=10436 $Y=-1376 $D=0
M196 23 22 69 VDD! pmos_rvt L=2e-08 W=1.08e-07 nfin=4 $X=10436 $Y=792 $D=0
M197 118 23 VDD! VDD! pmos_rvt L=2e-08 W=1.08e-07 nfin=4 $X=10652 $Y=-3544 $D=0
M198 120 5 25 VDD! pmos_rvt L=2e-08 W=1.08e-07 nfin=4 $X=10652 $Y=-1376 $D=0
M199 122 6 23 VDD! pmos_rvt L=2e-08 W=1.08e-07 nfin=4 $X=10652 $Y=792 $D=0
M200 26 7 118 VDD! pmos_rvt L=2e-08 W=1.08e-07 nfin=4 $X=10868 $Y=-3544 $D=0
M201 124 17 120 VDD! pmos_rvt L=2e-08 W=1.08e-07 nfin=4 $X=10868 $Y=-1376 $D=0
M202 126 18 122 VDD! pmos_rvt L=2e-08 W=1.08e-07 nfin=4 $X=10868 $Y=792 $D=0
M203 VDD! 19 124 VDD! pmos_rvt L=2e-08 W=1.08e-07 nfin=4 $X=11084 $Y=-1376 $D=0
M204 VDD! 20 126 VDD! pmos_rvt L=2e-08 W=1.08e-07 nfin=4 $X=11084 $Y=792 $D=0
M205 128 24 26 VDD! pmos_rvt L=2e-08 W=1.08e-07 nfin=4 $X=11516 $Y=-3544 $D=0
M206 VDD! 25 128 VDD! pmos_rvt L=2e-08 W=1.08e-07 nfin=4 $X=11732 $Y=-3544 $D=0
M207 OUT1 26 VDD! VDD! pmos_rvt L=2e-08 W=1.08e-07 nfin=4 $X=11948 $Y=-3544 $D=0
M208 130 B2 VDD! VDD! pmos_rvt L=2e-08 W=1.08e-07 nfin=4 $X=12164 $Y=-1376 $D=0
M209 132 B2 VDD! VDD! pmos_rvt L=2e-08 W=1.08e-07 nfin=4 $X=12164 $Y=792 $D=0
M210 30 A2 130 VDD! pmos_rvt L=2e-08 W=1.08e-07 nfin=4 $X=12380 $Y=-1376 $D=0
M211 31 A2 132 VDD! pmos_rvt L=2e-08 W=1.08e-07 nfin=4 $X=12380 $Y=792 $D=0
M212 72 21 30 VDD! pmos_rvt L=2e-08 W=1.08e-07 nfin=4 $X=12596 $Y=-1376 $D=0
M213 74 22 31 VDD! pmos_rvt L=2e-08 W=1.08e-07 nfin=4 $X=12596 $Y=792 $D=0
M214 VDD! A2 72 VDD! pmos_rvt L=2e-08 W=1.08e-07 nfin=4 $X=12812 $Y=-1376 $D=0
M215 VDD! A2 74 VDD! pmos_rvt L=2e-08 W=1.08e-07 nfin=4 $X=12812 $Y=792 $D=0
M216 72 B2 VDD! VDD! pmos_rvt L=2e-08 W=1.08e-07 nfin=4 $X=13028 $Y=-1376 $D=0
M217 74 B2 VDD! VDD! pmos_rvt L=2e-08 W=1.08e-07 nfin=4 $X=13028 $Y=792 $D=0
M218 16 C_IN VDD! VDD! pmos_rvt L=2e-08 W=1.08e-07 nfin=4 $X=13892 $Y=-3544 $D=0
M219 76 A2 VDD! VDD! pmos_rvt L=2e-08 W=1.08e-07 nfin=4 $X=14108 $Y=-1376 $D=0
M220 78 A2 VDD! VDD! pmos_rvt L=2e-08 W=1.08e-07 nfin=4 $X=14108 $Y=792 $D=0
M221 VDD! B2 76 VDD! pmos_rvt L=2e-08 W=1.08e-07 nfin=4 $X=14324 $Y=-1376 $D=0
M222 VDD! B2 78 VDD! pmos_rvt L=2e-08 W=1.08e-07 nfin=4 $X=14324 $Y=792 $D=0
M223 76 21 VDD! VDD! pmos_rvt L=2e-08 W=1.08e-07 nfin=4 $X=14540 $Y=-1376 $D=0
M224 78 22 VDD! VDD! pmos_rvt L=2e-08 W=1.08e-07 nfin=4 $X=14540 $Y=792 $D=0
M225 34 30 76 VDD! pmos_rvt L=2e-08 W=1.08e-07 nfin=4 $X=14756 $Y=-1376 $D=0
M226 35 31 78 VDD! pmos_rvt L=2e-08 W=1.08e-07 nfin=4 $X=14756 $Y=792 $D=0
M227 32 16 VDD! VDD! pmos_rvt L=2e-08 W=1.08e-07 nfin=4 $X=14972 $Y=-3544 $D=0
M228 135 21 34 VDD! pmos_rvt L=2e-08 W=1.08e-07 nfin=4 $X=14972 $Y=-1376 $D=0
M229 137 22 35 VDD! pmos_rvt L=2e-08 W=1.08e-07 nfin=4 $X=14972 $Y=792 $D=0
M230 140 B2 135 VDD! pmos_rvt L=2e-08 W=1.08e-07 nfin=4 $X=15188 $Y=-1376 $D=0
M231 142 B2 137 VDD! pmos_rvt L=2e-08 W=1.08e-07 nfin=4 $X=15188 $Y=792 $D=0
M232 VDD! A2 140 VDD! pmos_rvt L=2e-08 W=1.08e-07 nfin=4 $X=15404 $Y=-1376 $D=0
M233 VDD! A2 142 VDD! pmos_rvt L=2e-08 W=1.08e-07 nfin=4 $X=15404 $Y=792 $D=0
M234 VDD! 32 36 VDD! pmos_rvt L=2e-08 W=1.08e-07 nfin=4 $X=16052 $Y=-3544 $D=0
M235 144 33 VDD! VDD! pmos_rvt L=2e-08 W=1.08e-07 nfin=4 $X=16268 $Y=-3544 $D=0
M236 38 32 144 VDD! pmos_rvt L=2e-08 W=1.08e-07 nfin=4 $X=16484 $Y=-3544 $D=0
M237 37 34 VDD! VDD! pmos_rvt L=2e-08 W=1.08e-07 nfin=4 $X=16484 $Y=-1376 $D=0
M238 33 35 VDD! VDD! pmos_rvt L=2e-08 W=1.08e-07 nfin=4 $X=16484 $Y=792 $D=0
M239 148 36 38 VDD! pmos_rvt L=2e-08 W=1.08e-07 nfin=4 $X=17132 $Y=-3544 $D=0
M240 VDD! 37 148 VDD! pmos_rvt L=2e-08 W=1.08e-07 nfin=4 $X=17348 $Y=-3544 $D=0
M241 OUT2 38 VDD! VDD! pmos_rvt L=2e-08 W=1.08e-07 nfin=4 $X=17564 $Y=-3544 $D=0
M242 43 B3 VDD! VDD! pmos_rvt L=2e-08 W=1.08e-07 nfin=4 $X=17564 $Y=-1376 $D=0
M243 44 B3 VDD! VDD! pmos_rvt L=2e-08 W=1.08e-07 nfin=4 $X=17564 $Y=792 $D=0
M244 VDD! 32 42 VDD! pmos_rvt L=2e-08 W=1.08e-07 nfin=4 $X=18644 $Y=-3544 $D=0
M245 46 A3 VDD! VDD! pmos_rvt L=2e-08 W=1.08e-07 nfin=4 $X=18644 $Y=-1376 $D=0
M246 47 A3 VDD! VDD! pmos_rvt L=2e-08 W=1.08e-07 nfin=4 $X=18644 $Y=792 $D=0
M247 152 41 VDD! VDD! pmos_rvt L=2e-08 W=1.08e-07 nfin=4 $X=18860 $Y=-3544 $D=0
M248 48 32 152 VDD! pmos_rvt L=2e-08 W=1.08e-07 nfin=4 $X=19076 $Y=-3544 $D=0
M249 156 42 48 VDD! pmos_rvt L=2e-08 W=1.08e-07 nfin=4 $X=19724 $Y=-3544 $D=0
M250 158 43 VDD! VDD! pmos_rvt L=2e-08 W=1.08e-07 nfin=4 $X=19724 $Y=-1376 $D=0
M251 160 44 VDD! VDD! pmos_rvt L=2e-08 W=1.08e-07 nfin=4 $X=19724 $Y=792 $D=0
M252 VDD! 45 156 VDD! pmos_rvt L=2e-08 W=1.08e-07 nfin=4 $X=19940 $Y=-3544 $D=0
M253 45 46 158 VDD! pmos_rvt L=2e-08 W=1.08e-07 nfin=4 $X=19940 $Y=-1376 $D=0
M254 41 47 160 VDD! pmos_rvt L=2e-08 W=1.08e-07 nfin=4 $X=19940 $Y=792 $D=0
M255 C_OUT 48 VDD! VDD! pmos_rvt L=2e-08 W=1.08e-07 nfin=4 $X=20156 $Y=-3544 $D=0
M256 82 30 45 VDD! pmos_rvt L=2e-08 W=1.08e-07 nfin=4 $X=20156 $Y=-1376 $D=0
M257 84 31 41 VDD! pmos_rvt L=2e-08 W=1.08e-07 nfin=4 $X=20156 $Y=792 $D=0
M258 VDD! 46 82 VDD! pmos_rvt L=2e-08 W=1.08e-07 nfin=4 $X=20372 $Y=-1376 $D=0
M259 VDD! 47 84 VDD! pmos_rvt L=2e-08 W=1.08e-07 nfin=4 $X=20372 $Y=792 $D=0
M260 82 43 VDD! VDD! pmos_rvt L=2e-08 W=1.08e-07 nfin=4 $X=20588 $Y=-1376 $D=0
M261 84 44 VDD! VDD! pmos_rvt L=2e-08 W=1.08e-07 nfin=4 $X=20588 $Y=792 $D=0
M262 VDD! 32 50 VDD! pmos_rvt L=2e-08 W=1.08e-07 nfin=4 $X=21236 $Y=-3544 $D=0
M263 162 49 VDD! VDD! pmos_rvt L=2e-08 W=1.08e-07 nfin=4 $X=21452 $Y=-3544 $D=0
M264 52 32 162 VDD! pmos_rvt L=2e-08 W=1.08e-07 nfin=4 $X=21668 $Y=-3544 $D=0
M265 86 46 VDD! VDD! pmos_rvt L=2e-08 W=1.08e-07 nfin=4 $X=21668 $Y=-1376 $D=0
M266 88 47 VDD! VDD! pmos_rvt L=2e-08 W=1.08e-07 nfin=4 $X=21668 $Y=792 $D=0
M267 VDD! 43 86 VDD! pmos_rvt L=2e-08 W=1.08e-07 nfin=4 $X=21884 $Y=-1376 $D=0
M268 VDD! 44 88 VDD! pmos_rvt L=2e-08 W=1.08e-07 nfin=4 $X=21884 $Y=792 $D=0
M269 86 30 VDD! VDD! pmos_rvt L=2e-08 W=1.08e-07 nfin=4 $X=22100 $Y=-1376 $D=0
M270 88 31 VDD! VDD! pmos_rvt L=2e-08 W=1.08e-07 nfin=4 $X=22100 $Y=792 $D=0
M271 164 50 52 VDD! pmos_rvt L=2e-08 W=1.08e-07 nfin=4 $X=22316 $Y=-3544 $D=0
M272 51 45 86 VDD! pmos_rvt L=2e-08 W=1.08e-07 nfin=4 $X=22316 $Y=-1376 $D=0
M273 49 41 88 VDD! pmos_rvt L=2e-08 W=1.08e-07 nfin=4 $X=22316 $Y=792 $D=0
M274 VDD! 51 164 VDD! pmos_rvt L=2e-08 W=1.08e-07 nfin=4 $X=22532 $Y=-3544 $D=0
M275 166 30 51 VDD! pmos_rvt L=2e-08 W=1.08e-07 nfin=4 $X=22532 $Y=-1376 $D=0
M276 168 31 49 VDD! pmos_rvt L=2e-08 W=1.08e-07 nfin=4 $X=22532 $Y=792 $D=0
M277 OUT3 52 VDD! VDD! pmos_rvt L=2e-08 W=1.08e-07 nfin=4 $X=22748 $Y=-3544 $D=0
M278 170 43 166 VDD! pmos_rvt L=2e-08 W=1.08e-07 nfin=4 $X=22748 $Y=-1376 $D=0
M279 172 44 168 VDD! pmos_rvt L=2e-08 W=1.08e-07 nfin=4 $X=22748 $Y=792 $D=0
M280 VDD! 46 170 VDD! pmos_rvt L=2e-08 W=1.08e-07 nfin=4 $X=22964 $Y=-1376 $D=0
M281 VDD! 47 172 VDD! pmos_rvt L=2e-08 W=1.08e-07 nfin=4 $X=22964 $Y=792 $D=0
.ENDS
***************************************
